* MEMRISTOR CIRCUIT - MODEL pershin.sub

* DEPENDENCIES:
.include C:\Users\javit\Desktop\tesis-lic\memristor_simulation\memristorsimulation_app/simulation_results/pershin_simulations/p_06_1773161162/pershin.sub

* COMPONENTS:
V1 vin gnd sin 0 5 1 0 0 0
R0 n12167_12400 n12400_12732 8.5m
R1 n12167_12400 n11461_12167 8.5m
xmem2 n12167_12400 n11936_12167 l2 memristor
xmem3 n12167_12400 n12086_12400 l3 memristor
R4 n12400_12732 n12086_12400 8.5m
xmem5 n12400_12732 n12485_12732 l5 memristor
R6 n12400_12732 n12732_14122 8.5m
R7 gnd n26087_26336 8.5m
R8 gnd n38102_38268 8.5m
R9 vin n4873_6102 8.5m
R10 vin n4873_6098 8.5m
R11 vin n37626_38198 8.5m
xmem12 vin n38198_39297 l12 memristor
R13 n57575_57640 n57094_57575 8.5m
R14 n57575_57640 n57094_57640 8.5m
R15 n57575_57640 n57094_57640 8.5m
xmem16 n57575_57640 n57094_57575 l16 memristor
R17 gnd n18555_18921 8.5m
R18 gnd n27571_28495 8.5m
xmem19 n28326_28321 n28326_28600 l19 memristor
R20 n28326_28321 n28178_28321 8.5m
R21 n28326_28321 n28321_28910 8.5m
xmem22 n28326_28321 n27948_28326 l22 memristor
xmem23 n28326_28600 n27948_28326 l23 memristor
xmem24 n28326_28600 n28600_28756 l24 memristor
xmem25 n28326_28600 n28910_28600 l25 memristor
xmem26 gnd n24039_24863 l26 memristor
R27 gnd n24039_24863 8.5m
xmem28 n35903_35710 n35543_35710 l28 memristor
R29 n35903_35710 n34093_35903 8.5m
R30 n35903_35710 n35543_35710 8.5m
xmem31 n35903_35710 n33609_35903 l31 memristor
xmem32 n35543_35710 n35537_35543 l32 memristor
R33 gnd n11019_10760 8.5m
R34 gnd n11019_11115 8.5m
R35 gnd n11019_10760 8.5m
R36 gnd n49091_49244 8.5m
R37 gnd n49244_49315 8.5m
xmem38 gnd n18555_18921 l38 memristor
xmem39 gnd n43570_43573 l39 memristor
xmem40 gnd n43573_43656 l40 memristor
xmem41 gnd n43573_43656 l41 memristor
R42 n35693_35695 n35695_36052 8.5m
xmem43 n35693_35695 n35693_36052 l43 memristor
R44 n35693_35695 n35695_35787 8.5m
R45 n35693_35695 n35436_35693 8.5m
R46 n35695_36052 n35693_36052 8.5m
xmem47 n35695_36052 n36052_36297 l47 memristor
xmem48 n35695_36052 n35695_35787 l48 memristor
xmem49 n47482_49016 n49016_49091 l49 memristor
R50 n47482_49016 n49016_49315 8.5m
xmem51 n47482_49016 n47482_49177 l51 memristor
R52 n47482_49016 n47359_47482 8.5m
xmem53 n49016_49091 n49016_49315 l53 memristor
xmem54 n49016_49091 n49091_49244 l54 memristor
R55 n49016_49091 n49091_49315 8.5m
R56 n41798_41962 n41962_42079 8.5m
R57 n41798_41962 n41798_42079 8.5m
R58 n41798_41962 gnd 8.5m
R59 n41798_41962 n40874_41798 8.5m
R60 n41798_41962 gnd 8.5m
R61 n41962_42079 gnd 8.5m
R62 n41962_42079 gnd 8.5m
xmem63 n41962_42079 gnd l63 memristor
R64 n41962_42079 n41798_42079 8.5m
xmem65 n41962_42079 gnd l65 memristor
xmem66 gnd n38102_38268 l66 memristor
xmem67 n3730_5103 n4229_5103 l67 memristor
R68 n3730_5103 n2274_3730 8.5m
R69 n3730_5103 n3561_3730 8.5m
R70 n3730_5103 n5103_5476 8.5m
R71 n4229_5103 n3734_4229 8.5m
xmem72 n4229_5103 n5103_5476 l72 memristor
xmem73 n4229_5103 n3564_4229 l73 memristor
R74 n57607_58082 n58082_58075 8.5m
R75 n57607_58082 n57551_57607 8.5m
R76 n57607_58082 n57608_57607 8.5m
R77 n57607_58082 n58082_58140 8.5m
R78 n58082_58075 n57551_58075 8.5m
R79 n58082_58075 n58082_58140 8.5m
xmem80 n58082_58075 n58075_58363 l80 memristor
R81 n15325_15073 n15073_15152 8.5m
R82 n15325_15073 n14704_15325 8.5m
xmem83 n15325_15073 n14705_15073 l83 memristor
R84 n15325_15073 n15325_15486 8.5m
xmem85 n15073_15152 n15152_15486 l85 memristor
R86 n15073_15152 n14705_15073 8.5m
R87 n15073_15152 n15154_15152 8.5m
R88 n21122_21127 n21122_22059 8.5m
xmem89 n21122_21127 n21127_21210 l89 memristor
R90 n21122_21127 n21127_21210 8.5m
R91 n21122_21127 n20305_21122 8.5m
xmem92 n21122_22059 n21857_22059 l92 memristor
R93 n21122_22059 n20305_21122 8.5m
xmem94 n21122_22059 n22059_23422 l94 memristor
xmem95 gnd n10453_12542 l95 memristor
R96 gnd n12542_11517 8.5m
R97 gnd n43570_43573 8.5m
R98 gnd n43570_43782 8.5m
R99 n17038_17543 n17543_17819 8.5m
R100 n17038_17543 n15081_17038 8.5m
xmem101 n17038_17543 n17038_17039 l101 memristor
R102 n17038_17543 n17543_17616 8.5m
xmem103 n17543_17819 n17819_18516 l103 memristor
R104 n17543_17819 n17133_17819 8.5m
xmem105 n17543_17819 n17543_17616 l105 memristor
xmem106 gnd n18555_18921 l106 memristor
R107 n20981_21270 n21270_21739 8.5m
R108 n20981_21270 n20981_21739 8.5m
xmem109 n20981_21270 n21577_21270 l109 memristor
R110 n20981_21270 n20764_20981 8.5m
R111 n21270_21739 n20981_21739 8.5m
R112 n21270_21739 n21739_22806 8.5m
R113 n21270_21739 n21083_21739 8.5m
R114 n21270_21739 n21577_21270 8.5m
R115 n15538_15383 n15383_16081 8.5m
R116 n15538_15383 n13730_15383 8.5m
xmem117 n15538_15383 n15538_15691 l117 memristor
R118 n15538_15383 n13446_15538 8.5m
R119 n15383_16081 n13730_15383 8.5m
R120 n15383_16081 n16081_16878 8.5m
R121 n15383_16081 n16081_15691 8.5m
R122 n54359_54303 n54359_54788 8.5m
xmem123 n54359_54303 n54146_54359 l123 memristor
R124 n54359_54303 n54303_54363 8.5m
xmem125 n54359_54303 n54146_54303 l125 memristor
R126 n54359_54788 n54788_55154 8.5m
xmem127 n54359_54788 n54189_54788 l127 memristor
R128 n54359_54788 n54146_54359 8.5m
xmem129 vin n9166_9395 l129 memristor
R130 vin n23966_24040 8.5m
R131 vin n23966_24040 8.5m
xmem132 n27715_28152 n27839_28152 l132 memristor
R133 n27715_28152 n26704_27715 8.5m
xmem134 n27715_28152 n28152_29084 l134 memristor
R135 n27715_28152 n27715_27839 8.5m
R136 n27839_28152 n27715_27839 8.5m
R137 n27839_28152 n28152_29084 8.5m
R138 n27839_28152 n27844_27839 8.5m
R139 n30492_32277 n32277_32272 8.5m
R140 n30492_32277 n32277_32357 8.5m
R141 n30492_32277 n30369_30492 8.5m
R142 n30492_32277 n30320_30492 8.5m
xmem143 n32277_32272 n31668_32272 l143 memristor
xmem144 n32277_32272 n32272_32849 l144 memristor
xmem145 n32277_32272 n32277_32357 l145 memristor
xmem146 n32565_32721 n32721_33478 l146 memristor
R147 n32565_32721 n32565_32888 8.5m
xmem148 n32565_32721 n32721_33274 l148 memristor
R149 n32565_32721 n31438_32565 8.5m
R150 n32721_33478 n33478_34475 8.5m
xmem151 n32721_33478 n32721_33274 l151 memristor
R152 n32721_33478 n33478_33274 8.5m
xmem153 gnd n11019_11115 l153 memristor
R154 n22700_22797 n22797_23673 8.5m
R155 n22700_22797 n21081_22700 8.5m
R156 n22700_22797 n22700_22888 8.5m
R157 n22700_22797 n22797_22798 8.5m
xmem158 n22797_23673 n23673_23682 l158 memristor
xmem159 n22797_23673 n22797_22798 l159 memristor
R160 n22797_23673 n23673_24902 8.5m
R161 n29385_29901 n29901_30027 8.5m
R162 n29385_29901 n28688_29385 8.5m
R163 n29385_29901 n29289_29385 8.5m
xmem164 n29385_29901 n29638_29901 l164 memristor
R165 n29901_30027 n29638_30027 8.5m
R166 n29901_30027 n30027_30177 8.5m
R167 n29901_30027 n29638_29901 8.5m
xmem168 n8184_8974 n8974_9550 l168 memristor
R169 n8184_8974 n8524_8974 8.5m
xmem170 n8184_8974 n8184_8524 l170 memristor
R171 n8184_8974 n8057_8184 8.5m
xmem172 n8974_9550 n8524_8974 l172 memristor
R173 n8974_9550 n8609_9550 8.5m
R174 n8974_9550 n9550_10349 8.5m
R175 n33755_33936 n33936_34220 8.5m
R176 n33755_33936 n33755_34230 8.5m
xmem177 n33755_33936 n34230_33936 l177 memristor
R178 n33755_33936 n33267_33755 8.5m
R179 n33936_34220 n34230_33936 8.5m
xmem180 n33936_34220 n34304_34220 l180 memristor
R181 n33936_34220 n34220_36207 8.5m
R182 gnd n52974_53153 8.5m
xmem183 gnd n52816_53153 l183 memristor
R184 n11839_12603 n12603_15342 8.5m
xmem185 n11839_12603 n11404_11839 l185 memristor
R186 n11839_12603 n12603_15093 8.5m
R187 n11839_12603 n11585_11839 8.5m
R188 n12603_15342 n15093_15342 8.5m
R189 n12603_15342 n12603_15093 8.5m
xmem190 n12603_15342 n15749_15342 l190 memristor
R191 n37936_38200 n37936_39308 8.5m
R192 n37936_38200 n37738_38200 8.5m
R193 n37936_38200 n38200_39297 8.5m
R194 n37936_38200 n37738_37936 8.5m
R195 n37936_39308 n39308_39485 8.5m
R196 n37936_39308 n39308_39652 8.5m
xmem197 n37936_39308 n37738_37936 l197 memristor
R198 n37145_37529 n37529_38293 8.5m
R199 n37145_37529 n37529_37388 8.5m
R200 n37145_37529 n37145_37388 8.5m
R201 n37145_37529 n36475_37145 8.5m
R202 n37529_38293 n38293_38921 8.5m
xmem203 n37529_38293 n38360_38293 l203 memristor
R204 n37529_38293 n37529_37388 8.5m
R205 gnd n24039_24863 8.5m
R206 gnd n38618_40881 8.5m
R207 gnd n40881_40874 8.5m
xmem208 n32022_32125 n32125_32463 l208 memristor
xmem209 n32022_32125 n32125_32789 l209 memristor
R210 n32022_32125 n31206_32022 8.5m
R211 n32022_32125 n31426_32022 8.5m
xmem212 n32125_32463 n32125_32789 l212 memristor
xmem213 n32125_32463 n32789_32463 l213 memristor
R214 n32125_32463 n32463_33921 8.5m
R215 gnd n41798_42079 8.5m
R216 gnd n46858_46915 8.5m
R217 gnd n46915_47359 8.5m
R218 n56147_57678 n57678_57861 8.5m
R219 n56147_57678 n57678_58160 8.5m
R220 n56147_57678 n56147_56063 8.5m
R221 n56147_57678 n55677_56147 8.5m
xmem222 n57678_57861 n57861_58344 l222 memristor
R223 n57678_57861 n57678_58160 8.5m
R224 n57678_57861 n57861_58344 8.5m
R225 vin n17568_17957 8.5m
R226 vin n17171_17568 8.5m
R227 vin n29961_30300 8.5m
R228 vin n30186_30300 8.5m
R229 n24111_24663 n25473_24663 8.5m
R230 n24111_24663 n24859_24663 8.5m
xmem231 n24111_24663 n23520_24111 l231 memristor
R232 n24111_24663 n23422_24111 8.5m
R233 n25473_24663 n25473_26212 8.5m
R234 n25473_24663 n24859_24663 8.5m
R235 n25473_24663 n21207_25473 8.5m
R236 n45995_46463 n46395_46463 8.5m
xmem237 n45995_46463 n45996_46463 l237 memristor
R238 n45995_46463 n45995_45996 8.5m
xmem239 n45995_46463 n45840_45995 l239 memristor
xmem240 n46395_46463 n45992_46395 l240 memristor
xmem241 n46395_46463 n45996_46463 l241 memristor
R242 n46395_46463 n45994_46395 8.5m
R243 n21452_20440 n20340_20440 8.5m
xmem244 n21452_20440 n21452_21958 l244 memristor
R245 n21452_20440 n20014_20440 8.5m
xmem246 n21452_20440 n19479_21452 l246 memristor
R247 n20340_20440 n19713_20340 8.5m
R248 n20340_20440 n20340_21060 8.5m
R249 n20340_20440 n20014_20440 8.5m
xmem250 n14539_15088 n15087_15088 l250 memristor
R251 n14539_15088 n14214_14539 8.5m
R252 n14539_15088 n15088_15893 8.5m
R253 n14539_15088 n14539_14543 8.5m
R254 n15087_15088 n15087_15417 8.5m
R255 n15087_15088 n15088_15893 8.5m
xmem256 n15087_15088 n14359_15087 l256 memristor
R257 n137_234 vin 8.5m
xmem258 n137_234 n137_223 l258 memristor
R259 n137_234 vin 8.5m
R260 n137_234 n223_234 8.5m
R261 n137_234 n234_363 8.5m
R262 vin n137_223 8.5m
R263 n14276_14705 n14705_15073 8.5m
xmem264 n14276_14705 n13765_14276 l264 memristor
xmem265 n14276_14705 n14276_14350 l265 memristor
xmem266 n14276_14705 n14704_14705 l266 memristor
R267 n14705_15073 n14704_14705 8.5m
R268 n19066_21112 n21112_21207 8.5m
R269 n19066_21112 n19066_19528 8.5m
R270 n19066_21112 n17834_19066 8.5m
R271 n19066_21112 n21112_21676 8.5m
R272 n21112_21207 n21207_25473 8.5m
R273 n21112_21207 n21112_21676 8.5m
xmem274 n21112_21207 n21022_21207 l274 memristor
R275 n22579_23355 n23355_23358 8.5m
R276 n22579_23355 n22285_22579 8.5m
R277 n22579_23355 n23355_23347 8.5m
xmem278 n22579_23355 n22579_23072 l278 memristor
xmem279 n23355_23358 n23355_23347 l279 memristor
R280 n23355_23358 n23358_23755 8.5m
R281 n23355_23358 n22780_23358 8.5m
R282 n55563_55696 n55696_55853 8.5m
xmem283 n55563_55696 n55696_56258 l283 memristor
xmem284 n55563_55696 n55563_54936 l284 memristor
R285 n55563_55696 n53279_55563 8.5m
R286 n55696_55853 n55853_56181 8.5m
xmem287 n55696_55853 n55696_56258 l287 memristor
R288 n55696_55853 n55846_55853 8.5m
xmem289 n57021_57017 n57017_58255 l289 memristor
R290 n57021_57017 n56955_57021 8.5m
xmem291 n57021_57017 n57009_57017 l291 memristor
xmem292 n57021_57017 n56863_57021 l292 memristor
R293 n57017_58255 n58255_58378 8.5m
R294 n57017_58255 n58019_58255 8.5m
R295 n57017_58255 n57009_57017 8.5m
R296 n32344_32436 n32436_32761 8.5m
xmem297 n32344_32436 n32266_32436 l297 memristor
R298 n32344_32436 n31663_32344 8.5m
R299 n32344_32436 n31988_32344 8.5m
xmem300 n32436_32761 n32761_32844 l300 memristor
xmem301 n32436_32761 n32266_32436 l301 memristor
R302 n32436_32761 n32266_32761 8.5m
R303 n13567_14697 n14697_14704 8.5m
xmem304 n13567_14697 n14697_14693 l304 memristor
xmem305 n13567_14697 n13108_13567 l305 memristor
R306 n13567_14697 n13567_14704 8.5m
R307 n14697_14704 n14704_14705 8.5m
R308 n14697_14704 n13567_14704 8.5m
xmem309 n14697_14704 n14704_15325 l309 memristor
R310 n14697_14704 n14697_14693 8.5m
R311 n18555_18921 gnd 8.5m
R312 n12542_11517 n11857_11517 8.5m
R313 n12542_11517 n10453_12542 8.5m
R314 n12542_11517 n11349_11517 8.5m
R315 n12542_11517 gnd 8.5m
R316 n11857_11517 n11349_11517 8.5m
R317 n11857_11517 n11853_11857 8.5m
R318 n11857_11517 n11349_11857 8.5m
R319 n37424_37709 n37709_38153 8.5m
xmem320 n37424_37709 n36957_37424 l320 memristor
xmem321 n37424_37709 n37490_37709 l321 memristor
R322 n37424_37709 n37424_38153 8.5m
R323 n37709_38153 n37490_37709 8.5m
R324 n37709_38153 n37424_38153 8.5m
R325 n37709_38153 n38153_38527 8.5m
xmem326 gnd n8129_7432 l326 memristor
xmem327 gnd n8129_8619 l327 memristor
xmem328 vin n17957_18081 l328 memristor
xmem329 vin n17568_17957 l329 memristor
R330 vin n20529_22548 8.5m
xmem331 vin n18559_20529 l331 memristor
R332 n56418_56523 n56523_56828 8.5m
xmem333 n56418_56523 n55987_56418 l333 memristor
R334 n56418_56523 n56418_56638 8.5m
xmem335 n56418_56523 n56359_56523 l335 memristor
xmem336 n56523_56828 n56359_56523 l336 memristor
xmem337 n56523_56828 n56638_56828 l337 memristor
xmem338 n56523_56828 n56828_56881 l338 memristor
R339 n10594_10323 n10594_11150 8.5m
R340 n10594_10323 n10105_10323 8.5m
R341 n10594_10323 n9766_10323 8.5m
xmem342 n10594_10323 n9443_10594 l342 memristor
R343 n10594_11150 n11150_11461 8.5m
xmem344 n10594_11150 n9443_10594 l344 memristor
R345 n10594_11150 n11150_12086 8.5m
xmem346 n29822_30577 n30577_30995 l346 memristor
R347 n29822_30577 n28756_29822 8.5m
R348 n29822_30577 n30076_30577 8.5m
R349 n29822_30577 n29822_29825 8.5m
xmem350 n30577_30995 n30157_30995 l350 memristor
xmem351 n30577_30995 n30076_30577 l351 memristor
R352 n30577_30995 n30995_31200 8.5m
R353 n14781_16203 n16203_16280 8.5m
xmem354 n14781_16203 n14781_15577 l354 memristor
R355 n14781_16203 n16047_16203 8.5m
xmem356 n14781_16203 n14543_14781 l356 memristor
xmem357 n16203_16280 n15978_16280 l357 memristor
R358 n16203_16280 n16047_16203 8.5m
R359 n16203_16280 n16280_16461 8.5m
R360 vin n18559_20529 8.5m
xmem361 vin n18081_18559 l361 memristor
R362 vin n29961_30186 8.5m
R363 vin n29961_30300 8.5m
R364 n22797_22798 n22798_22799 8.5m
R365 n22797_22798 n22798_22903 8.5m
R366 n22798_22799 n22799_22903 8.5m
R367 n22798_22799 n22798_22903 8.5m
xmem368 n22798_22799 n22806_22799 l368 memristor
xmem369 n22903_23272 n23171_23272 l369 memristor
R370 n22903_23272 n22799_22903 8.5m
R371 n22903_23272 n22798_22903 8.5m
R372 n22903_23272 n23272_23682 8.5m
R373 n23171_23272 n23277_23171 8.5m
xmem374 n23171_23272 n22806_23171 l374 memristor
R375 n23171_23272 n23272_23682 8.5m
R376 vin n223_234 8.5m
R377 vin n137_223 8.5m
R378 vin n22548_22748 8.5m
R379 vin n22748_23046 8.5m
R380 gnd n49091_49244 8.5m
R381 gnd n49244_49315 8.5m
xmem382 n46148_46152 n46148_46309 l382 memristor
xmem383 n46148_46152 n45329_46148 l383 memristor
xmem384 n46148_46152 n46152_46787 l384 memristor
R385 n46148_46152 n45799_46152 8.5m
R386 n46148_46309 n46309_46574 8.5m
xmem387 n46148_46309 n46309_46728 l387 memristor
R388 n46148_46309 n45329_46148 8.5m
R389 gnd n3473_4120 8.5m
R390 gnd n4047_4120 8.5m
xmem391 gnd n43656_44202 l391 memristor
R392 gnd n43782_44202 8.5m
R393 n10064_10287 n10287_11853 8.5m
R394 n10064_10287 n10064_9971 8.5m
xmem395 n10064_10287 n10286_10287 l395 memristor
R396 n10064_10287 n9384_10064 8.5m
R397 n10287_11853 n10286_10287 8.5m
R398 n10287_11853 n10652_11853 8.5m
xmem399 n10287_11853 n11853_11857 l399 memristor
xmem400 gnd n11019_11115 l400 memristor
xmem401 gnd n26087_26336 l401 memristor
xmem402 gnd n27571_28495 l402 memristor
xmem403 gnd n26444_27571 l403 memristor
R404 n20778_21600 n21600_21194 8.5m
xmem405 n20778_21600 n20778_21191 l405 memristor
xmem406 n20778_21600 n20496_20778 l406 memristor
R407 n20778_21600 n21600_24312 8.5m
R408 n21600_21194 n20845_21194 8.5m
R409 n21600_21194 n21395_21194 8.5m
xmem410 n21600_21194 n21600_24312 l410 memristor
xmem411 n25180_26276 n26276_26999 l411 memristor
xmem412 n25180_26276 n25180_25938 l412 memristor
xmem413 n25180_26276 n26276_26275 l413 memristor
R414 n25180_26276 n22788_25180 8.5m
R415 n26276_26999 n26276_26275 8.5m
xmem416 n26276_26999 n26999_27192 l416 memristor
R417 n26276_26999 n26380_26999 8.5m
R418 n41926_41282 n41282_42465 8.5m
R419 n41926_41282 n40771_41926 8.5m
R420 n41926_41282 n41926_42400 8.5m
R421 n41926_41282 n41282_42465 8.5m
xmem422 n41282_42465 n42465_42569 l422 memristor
R423 gnd n43573_43656 8.5m
R424 gnd n43573_43656 8.5m
xmem425 gnd n43656_44202 l425 memristor
R426 gnd n2598_2893 8.5m
xmem427 gnd n2893_2990 l427 memristor
R428 gnd n43782_44202 8.5m
R429 gnd n43656_44202 8.5m
R430 n52223_52229 n52229_52433 8.5m
xmem431 n52223_52229 n51563_52229 l431 memristor
R432 n52223_52229 n51563_52223 8.5m
R433 n52223_52229 n51750_52223 8.5m
xmem434 n52229_52433 n52433_52974 l434 memristor
R435 n52229_52433 n52433_52439 8.5m
xmem436 n52229_52433 n51563_52229 l436 memristor
xmem437 gnd n52440_52439 l437 memristor
R438 gnd n34501_34571 8.5m
xmem439 gnd n32250_34501 l439 memristor
R440 n13730_15383 n13450_13730 8.5m
R441 n13730_15383 n13450_13730 8.5m
R442 vin n16721_17171 8.5m
R443 vin n59153_59366 8.5m
xmem444 vin n59366_59369 l444 memristor
xmem445 n54052_54297 n54297_54555 l445 memristor
R446 n54052_54297 n54297_54474 8.5m
xmem447 n54052_54297 n54052_54477 l447 memristor
xmem448 n54052_54297 n53935_54052 l448 memristor
xmem449 n54297_54555 n54555_54740 l449 memristor
xmem450 n54297_54555 n54297_54474 l450 memristor
R451 n54297_54555 n54555_56506 8.5m
xmem452 gnd n11019_11115 l452 memristor
xmem453 gnd n34501_34571 l453 memristor
R454 gnd n32913_34571 8.5m
R455 n37691_37806 n37806_39229 8.5m
xmem456 n37691_37806 n36621_37691 l456 memristor
xmem457 n37806_39229 n39593_39229 l457 memristor
xmem458 n37806_39229 n37691_37806 l458 memristor
R459 n37806_39229 n39068_39229 8.5m
R460 n32789_32463 n32789_33259 8.5m
R461 n32789_32463 n32125_32789 8.5m
xmem462 n32789_32463 n32463_33921 l462 memristor
R463 n32789_33259 n32125_32789 8.5m
R464 n32789_33259 n33259_33372 8.5m
xmem465 n32789_33259 n33259_34006 l465 memristor
xmem466 n1350_1440 n1544_1440 l466 memristor
R467 n1350_1440 n1440_1441 8.5m
R468 n1350_1440 n1350_1346 8.5m
R469 n1350_1440 n993_1350 8.5m
R470 n1544_1440 n1346_1544 8.5m
R471 n1544_1440 n1440_1441 8.5m
R472 n1544_1440 n1544_2913 8.5m
R473 n8482_7823 n7599_7823 8.5m
xmem474 n8482_7823 n8482_8841 l474 memristor
xmem475 n8482_7823 n7823_9582 l475 memristor
R476 n8482_7823 n5447_8482 8.5m
xmem477 n7599_7823 n7823_9582 l477 memristor
R478 n7599_7823 n7528_7599 8.5m
R479 n7599_7823 n7599_8316 8.5m
R480 vin n12444_12917 8.5m
R481 vin n13712_12917 8.5m
xmem482 n10726_11652 n11652_12258 l482 memristor
R483 n10726_11652 n10628_10726 8.5m
R484 n10726_11652 n11652_11651 8.5m
R485 n10726_11652 n10726_10727 8.5m
R486 n11652_12258 n12258_13774 8.5m
R487 n11652_12258 n11652_11651 8.5m
R488 n11652_12258 n10727_12258 8.5m
R489 n16956_18871 n18871_18948 8.5m
R490 n16956_18871 n16593_16956 8.5m
R491 n16956_18871 n18871_19656 8.5m
R492 n16956_18871 n16956_16955 8.5m
R493 n18871_18948 n18948_20354 8.5m
R494 n18871_18948 n18949_18948 8.5m
xmem495 n18871_18948 n18871_19656 l495 memristor
R496 n41521_41767 n41767_42994 8.5m
R497 n41521_41767 n41147_41521 8.5m
R498 n41521_41767 n41147_41521 8.5m
R499 n41521_41767 n41767_42874 8.5m
R500 n41767_42994 n42994_43270 8.5m
R501 n41767_42994 n41767_42874 8.5m
R502 n41767_42994 n42874_42994 8.5m
R503 n11150_12086 n12086_12485 8.5m
xmem504 n11150_12086 n12086_12400 l504 memristor
xmem505 n11150_12086 n11150_11461 l505 memristor
R506 n12086_12485 n12086_12400 8.5m
xmem507 n12086_12485 n12485_12732 l507 memristor
xmem508 n12086_12485 n12485_13108 l508 memristor
xmem509 n18516_18598 n18598_19600 l509 memristor
R510 n18516_18598 n17819_18516 8.5m
R511 n18516_18598 n18596_18598 8.5m
xmem512 n18516_18598 n18516_18690 l512 memristor
R513 n18598_19600 n18596_18598 8.5m
R514 n18598_19600 n18973_19600 8.5m
R515 n18598_19600 n19600_19891 8.5m
R516 n20237_20425 n20425_22750 8.5m
R517 n20237_20425 n20158_20237 8.5m
R518 n20237_20425 n20237_22451 8.5m
R519 n20237_20425 n20158_20425 8.5m
R520 n20425_22750 n22750_23058 8.5m
R521 n20425_22750 n22750_22757 8.5m
R522 n20425_22750 n20158_20425 8.5m
xmem523 n30913_31189 n31189_31267 l523 memristor
R524 n30913_31189 n30913_30641 8.5m
xmem525 n30913_31189 n30375_30913 l525 memristor
xmem526 n30913_31189 n31184_31189 l526 memristor
R527 n31189_31267 n31268_31267 8.5m
R528 n31189_31267 n31184_31189 8.5m
R529 n31189_31267 n31267_31541 8.5m
xmem530 n53831_53766 n53749_53766 l530 memristor
R531 n53831_53766 n53831_54196 8.5m
R532 n53831_53766 n53766_54196 8.5m
R533 n53831_53766 n53645_53831 8.5m
R534 n53749_53766 n53766_54196 8.5m
xmem535 n53749_53766 n54189_53749 l535 memristor
xmem536 n53749_53766 n53749_54146 l536 memristor
xmem537 vin n23966_24040 l537 memristor
xmem538 vin n23966_24040 l538 memristor
R539 n10628_10726 n10628_11172 8.5m
R540 n10628_10726 n10521_10628 8.5m
R541 n10628_10726 n10726_10727 8.5m
xmem542 n10628_11172 n11066_11172 l542 memristor
R543 n10628_11172 n10521_10628 8.5m
R544 n10628_11172 n11172_11651 8.5m
xmem545 n32073_32266 n32266_32761 l545 memristor
xmem546 n32073_32266 n31733_32073 l546 memristor
R547 n32073_32266 n31663_32073 8.5m
xmem548 n32073_32266 n32266_32436 l548 memristor
R549 n32266_32761 n32761_32844 8.5m
xmem550 n32266_32761 n32266_32436 l550 memristor
R551 vin n31451_31647 8.5m
xmem552 n23966_24040 vin l552 memristor
R553 n23966_24040 n23895_23966 8.5m
xmem554 vin n23966_24040 l554 memristor
R555 vin n23895_23966 8.5m
xmem556 n46858_46915 n46915_47359 l556 memristor
xmem557 n46858_46915 gnd l557 memristor
R558 n46858_46915 n46858_47359 8.5m
R559 n46915_47359 n47359_47482 8.5m
xmem560 n46915_47359 n46858_47359 l560 memristor
R561 gnd n43570_43782 8.5m
xmem562 gnd n43570_43573 l562 memristor
xmem563 n52341_52807 n52610_52807 l563 memristor
R564 n52341_52807 n52346_52341 8.5m
R565 n52341_52807 n52341_52610 8.5m
xmem566 n52341_52807 n52807_53084 l566 memristor
R567 n52610_52807 n52610_53028 8.5m
R568 n52610_52807 n52807_53084 8.5m
xmem569 n52610_52807 n52341_52610 l569 memristor
R570 vin n12367_13712 8.5m
R571 vin n12367_12444 8.5m
R572 n15087_15417 n14359_15087 8.5m
R573 n15087_15417 n15411_15417 8.5m
xmem574 n15087_15417 n15417_16194 l574 memristor
R575 n21081_20256 n21081_22700 8.5m
xmem576 n21081_20256 n19656_21081 l576 memristor
xmem577 n21081_20256 n20256_22888 l577 memristor
R578 n21081_20256 n19951_20256 8.5m
R579 n21081_22700 n19656_21081 8.5m
xmem580 n21081_22700 n22700_22888 l580 memristor
R581 n14244_14387 n14387_14960 8.5m
R582 n14244_14387 n14387_14487 8.5m
R583 n14244_14387 n13720_14244 8.5m
R584 n14244_14387 n14079_14244 8.5m
R585 n14387_14960 n14387_14487 8.5m
R586 n14387_14960 n14736_14960 8.5m
xmem587 n14387_14960 n15275_14960 l587 memristor
xmem588 n43782_44202 n43570_43782 l588 memristor
R589 n43782_44202 n43709_43782 8.5m
R590 n43782_44202 n43656_44202 8.5m
R591 n34453_34448 n34448_36207 8.5m
R592 n34453_34448 n34453_34622 8.5m
R593 n34453_34448 n34236_34448 8.5m
xmem594 n34453_34448 n33386_34453 l594 memristor
R595 n34448_36207 n36207_36656 8.5m
R596 n34448_36207 n34236_34448 8.5m
xmem597 n34448_36207 n34220_36207 l597 memristor
xmem598 n16231_16423 n16423_16658 l598 memristor
xmem599 n16231_16423 n16231_16499 l599 memristor
R600 n16231_16423 n16423_16497 8.5m
xmem601 n16231_16423 n16152_16231 l601 memristor
xmem602 n16423_16658 n16658_18305 l602 memristor
xmem603 n16423_16658 n16423_16497 l603 memristor
R604 n16423_16658 n16658_16497 8.5m
R605 n21257_21558 n21257_21888 8.5m
R606 n21257_21558 n21074_21257 8.5m
R607 n21257_21558 n20659_21558 8.5m
R608 n21257_21558 n21558_21888 8.5m
R609 n21257_21888 n21558_21888 8.5m
R610 n21257_21888 n21888_22788 8.5m
xmem611 n21257_21888 n21074_21257 l611 memristor
xmem612 vin n22548_22748 l612 memristor
R613 vin n22748_23046 8.5m
xmem614 n7945_8510 n8510_8509 l614 memristor
R615 n7945_8510 n6740_7945 8.5m
R616 n7945_8510 n7945_9227 8.5m
xmem617 n7945_8510 n8510_9034 l617 memristor
R618 n8510_8509 n8508_8509 8.5m
R619 n8510_8509 n8510_9034 8.5m
R620 n8510_8509 n8508_8509 8.5m
R621 n11878_11868 n11540_11868 8.5m
R622 n11878_11868 n8758_11878 8.5m
xmem623 n11878_11868 n11878_11882 l623 memristor
R624 n11878_11868 n11868_12781 8.5m
xmem625 n11540_11868 n11868_12781 l625 memristor
R626 n11540_11868 n8758_11540 8.5m
R627 n11540_11868 n11540_11690 8.5m
R628 n22663_22560 n22560_22761 8.5m
R629 n22663_22560 n22663_22855 8.5m
R630 n22560_22761 n22761_22768 8.5m
xmem631 n22560_22761 n22663_22560 l631 memristor
xmem632 n22560_22761 n22761_24412 l632 memristor
xmem633 n8863_9107 n8863_9533 l633 memristor
xmem634 n8863_9107 n8587_8863 l634 memristor
R635 n8863_9107 n8799_9107 8.5m
R636 n8863_9107 n9107_9533 8.5m
xmem637 n8863_9533 n9615_9533 l637 memristor
R638 n8863_9533 n9107_9533 8.5m
xmem639 n8863_9533 n8587_8863 l639 memristor
xmem640 n31930_33609 n33609_35903 l640 memristor
xmem641 n31930_33609 n31841_33609 l641 memristor
xmem642 n31930_33609 n31841_31930 l642 memristor
R643 n31930_33609 n31490_31930 8.5m
xmem644 n33609_35903 n31841_33609 l644 memristor
xmem645 n33609_35903 n34093_35903 l645 memristor
xmem646 vin n17568_17957 l646 memristor
R647 vin n17957_18081 8.5m
xmem648 n25689_26816 n26816_27285 l648 memristor
R649 n25689_26816 n26816_26291 8.5m
R650 n25689_26816 n24524_25689 8.5m
R651 n25689_26816 n25604_25689 8.5m
R652 n26816_27285 n27285_27948 8.5m
xmem653 n26816_27285 n26816_26291 l653 memristor
xmem654 n26816_27285 n27285_27283 l654 memristor
R655 n35441_35788 n35788_36302 8.5m
R656 n35441_35788 n33989_35441 8.5m
xmem657 n35441_35788 n35788_35787 l657 memristor
R658 n35441_35788 n33989_35441 8.5m
xmem659 n35788_36302 n36302_36568 l659 memristor
R660 n35788_36302 n35788_35787 8.5m
R661 n35788_36302 n36302_36428 8.5m
xmem662 n17473_18119 n18119_18498 l662 memristor
xmem663 n17473_18119 n17478_17473 l663 memristor
R664 n17473_18119 n17346_17473 8.5m
R665 n17473_18119 n18119_18419 8.5m
xmem666 n18119_18498 n18119_18419 l666 memristor
R667 n18119_18498 n18498_18766 8.5m
xmem668 n18119_18498 n18498_18419 l668 memristor
R669 n24312_24750 n24750_25548 8.5m
xmem670 n24312_24750 n24653_24750 l670 memristor
R671 n24312_24750 n24653_24312 8.5m
R672 n24312_24750 n21600_24312 8.5m
R673 n24750_25548 n25548_25816 8.5m
R674 n24750_25548 n24653_24750 8.5m
R675 n24750_25548 n25548_26665 8.5m
R676 n7446_7448 n7448_7813 8.5m
R677 n7446_7448 n7446_7441 8.5m
xmem678 n7446_7448 n7448_7813 l678 memristor
R679 n7446_7448 n7129_7446 8.5m
xmem680 n7448_7813 n7813_8465 l680 memristor
xmem681 n54572_55175 n55175_55230 l681 memristor
R682 n54572_55175 n54572_55241 8.5m
R683 n54572_55175 n55175_55174 8.5m
R684 n54572_55175 n54570_54572 8.5m
R685 n55175_55230 n55230_55234 8.5m
xmem686 n55175_55230 n55230_55683 l686 memristor
R687 n55175_55230 n55175_55174 8.5m
R688 gnd n27571_28495 8.5m
R689 n17215_16530 n16530_17600 8.5m
xmem690 n17215_16530 n15641_16530 l690 memristor
xmem691 n17215_16530 n17215_17478 l691 memristor
R692 n17215_16530 n15237_17215 8.5m
R693 n16530_17600 n17600_17616 8.5m
R694 n16530_17600 n15641_16530 8.5m
xmem695 n16530_17600 n17600_17744 l695 memristor
xmem696 n10453_10760 n10453_12542 l696 memristor
xmem697 n10453_10760 n11019_10760 l697 memristor
R698 n10453_10760 n8899_10453 8.5m
xmem699 n10453_10760 n11019_10760 l699 memristor
R700 n10453_12542 n8899_10453 8.5m
R701 n10453_12542 gnd 8.5m
R702 n15978_16280 n15978_18896 8.5m
xmem703 n15978_16280 n15978_16400 l703 memristor
xmem704 n15978_16280 n16280_16461 l704 memristor
R705 n15978_18896 n18896_19208 8.5m
xmem706 n15978_18896 n15978_16400 l706 memristor
xmem707 n15978_18896 n18896_17935 l707 memristor
R708 n22798_22903 n22799_22903 8.5m
xmem709 n31526_31800 n31800_33328 l709 memristor
R710 n31526_31800 n31464_31526 8.5m
R711 n31800_33328 n33332_33328 8.5m
R712 n31800_33328 n31526_31800 8.5m
R713 n31800_33328 n33328_35140 8.5m
xmem714 n35537_35543 n35543_35710 l714 memristor
xmem715 n35537_35543 n35529_35537 l715 memristor
xmem716 n35537_35543 n35537_36313 l716 memristor
R717 gnd n2598_2893 8.5m
R718 n23355_23347 n23072_23347 8.5m
xmem719 n23355_23347 n23347_25033 l719 memristor
R720 n23072_23347 n22875_23072 8.5m
xmem721 n23072_23347 n22579_23072 l721 memristor
xmem722 n23072_23347 n23347_25033 l722 memristor
R723 n28178_28321 n28178_28256 8.5m
xmem724 n28178_28321 n28321_28910 l724 memristor
xmem725 n28178_28321 n27672_28178 l725 memristor
xmem726 n55230_55234 n55183_55234 l726 memristor
R727 n55230_55234 n55230_55683 8.5m
R728 n55230_55234 n55234_55372 8.5m
R729 n34424_34917 n34424_34916 8.5m
R730 n34424_34917 n34917_35348 8.5m
xmem731 n34424_34917 n33971_34424 l731 memristor
R732 n34424_34917 n34917_34916 8.5m
xmem733 n34424_34916 n34916_35344 l733 memristor
xmem734 n34424_34916 n34917_34916 l734 memristor
xmem735 n34424_34916 n33971_34424 l735 memristor
xmem736 n29126_27536 n27536_27541 l736 memristor
xmem737 n29126_27536 n26917_27536 l737 memristor
R738 n29126_27536 n29126_29463 8.5m
R739 n29126_27536 n26629_29126 8.5m
R740 n27536_27541 n26917_27536 8.5m
R741 n27536_27541 n27541_29284 8.5m
xmem742 n27536_27541 n26752_27541 l742 memristor
R743 n27143_27386 n27386_27814 8.5m
R744 n27143_27386 n25887_27143 8.5m
xmem745 n27143_27386 n27143_27879 l745 memristor
R746 n27143_27386 n26653_27386 8.5m
R747 n27386_27814 n27879_27814 8.5m
xmem748 n27386_27814 n26653_27386 l748 memristor
xmem749 n27386_27814 n27814_28766 l749 memristor
R750 n53831_54196 n53645_53831 8.5m
R751 n53831_54196 n54196_54255 8.5m
xmem752 n53831_54196 n53766_54196 l752 memristor
R753 n21666_24935 n24935_24648 8.5m
R754 n21666_24935 n24935_25265 8.5m
xmem755 n21666_24935 n21666_21983 l755 memristor
xmem756 n21666_24935 n20376_21666 l756 memristor
xmem757 n24935_24648 n23711_24648 l757 memristor
xmem758 n24935_24648 n24935_25265 l758 memristor
R759 n24935_24648 n24648_24637 8.5m
R760 n39910_40276 n40449_40276 8.5m
R761 n39910_40276 n39664_39910 8.5m
R762 n39910_40276 n40203_40276 8.5m
R763 n39910_40276 n39910_40449 8.5m
R764 n40449_40276 n40203_40276 8.5m
xmem765 n40449_40276 n40449_40563 l765 memristor
R766 n40449_40276 n39910_40449 8.5m
R767 n20712_20223 n20712_21034 8.5m
R768 n20712_20223 n20712_21417 8.5m
xmem769 n20712_20223 n20223_20936 l769 memristor
xmem770 n20712_20223 n20223_21310 l770 memristor
R771 n20712_21034 n20936_21034 8.5m
xmem772 n20712_21034 n21034_21417 l772 memristor
R773 n20712_21034 n20712_21417 8.5m
xmem774 n15325_15486 n15486_15641 l774 memristor
R775 n15325_15486 n15152_15486 8.5m
xmem776 n15325_15486 n14704_15325 l776 memristor
xmem777 n15486_15641 n15154_15641 l777 memristor
xmem778 n15486_15641 n15152_15486 l778 memristor
xmem779 n15486_15641 n15641_16530 l779 memristor
xmem780 n30913_30641 n30375_30913 l780 memristor
R781 n30913_30641 n30641_30987 8.5m
R782 n30913_30641 n30381_30641 8.5m
xmem783 n25881_25613 n25193_25613 l783 memristor
xmem784 n25881_25613 n24084_25881 l784 memristor
R785 n25881_25613 n25613_26743 8.5m
R786 n25881_25613 n25881_26823 8.5m
xmem787 n25193_25613 n25613_26743 l787 memristor
R788 n25193_25613 n24991_25193 8.5m
R789 n25193_25613 n24534_25193 8.5m
xmem790 n56181_56937 n56258_56937 l790 memristor
R791 n56181_56937 n56181_56258 8.5m
xmem792 n56181_56937 n55853_56181 l792 memristor
xmem793 n56181_56937 n55846_56937 l793 memristor
R794 n56258_56937 n55696_56258 8.5m
R795 n56258_56937 n55846_56937 8.5m
R796 n56258_56937 n56181_56258 8.5m
R797 n23542_31464 n31464_31980 8.5m
R798 n23542_31464 n23542_23631 8.5m
xmem799 n23542_31464 n31464_31526 l799 memristor
xmem800 n23542_31464 n23058_23542 l800 memristor
R801 n31464_31980 n31980_32837 8.5m
R802 n31464_31980 n31980_31982 8.5m
R803 n31464_31980 n31464_31526 8.5m
xmem804 n11439_11532 n11532_12054 l804 memristor
xmem805 n11439_11532 n11532_11690 l805 memristor
xmem806 n11439_11532 n11433_11439 l806 memristor
R807 n11439_11532 n11210_11439 8.5m
R808 n11532_12054 n11532_11690 8.5m
R809 n11532_12054 n12054_12458 8.5m
R810 n11532_12054 n12054_13076 8.5m
xmem811 n38871_38935 n38872_38935 l811 memristor
xmem812 n38871_38935 n38935_40533 l812 memristor
xmem813 n38871_38935 n38527_38871 l813 memristor
xmem814 n38871_38935 n38529_38871 l814 memristor
R815 n38872_38935 n38935_40533 8.5m
xmem816 n38872_38935 n38529_38872 l816 memristor
xmem817 n38872_38935 n36721_38872 l817 memristor
R818 n19733_19732 n19732_19881 8.5m
xmem819 n19733_19732 n18963_19733 l819 memristor
xmem820 n19733_19732 n19733_21577 l820 memristor
R821 n19733_19732 n19036_19732 8.5m
R822 n19732_19881 n19036_19732 8.5m
R823 n19732_19881 n19881_20577 8.5m
R824 n19732_19881 n19339_19881 8.5m
R825 n34622_35105 n35105_36747 8.5m
xmem826 n34622_35105 n35032_35105 l826 memristor
xmem827 n34622_35105 n34551_34622 l827 memristor
R828 n34622_35105 n34453_34622 8.5m
R829 n35105_36747 n35032_35105 8.5m
xmem830 n35105_36747 n36747_37205 l830 memristor
xmem831 n35105_36747 n36747_36743 l831 memristor
R832 n50309_50794 n50601_50794 8.5m
R833 n50309_50794 n50108_50309 8.5m
xmem834 n50309_50794 n50601_50794 l834 memristor
xmem835 n50309_50794 n50210_50309 l835 memristor
R836 n50601_50794 n50210_50601 8.5m
xmem837 n30867_31438 n31438_32565 l837 memristor
xmem838 n30867_31438 n30177_30867 l838 memristor
R839 n30867_31438 n30867_30868 8.5m
R840 n30867_31438 n31435_31438 8.5m
R841 n31438_32565 n31435_31438 8.5m
xmem842 n31438_32565 n32565_32888 l842 memristor
R843 n28619_28551 n28551_28352 8.5m
R844 n28619_28551 n28619_28195 8.5m
R845 n28619_28551 n27823_28551 8.5m
R846 n28619_28551 n27228_28619 8.5m
xmem847 n28551_28352 n28352_28355 l847 memristor
R848 n28551_28352 n28052_28352 8.5m
R849 n28551_28352 n27823_28551 8.5m
R850 n56350_56578 n56578_57009 8.5m
R851 n56350_56578 n55640_56350 8.5m
R852 n56350_56578 n56350_56863 8.5m
xmem853 n56350_56578 n56573_56578 l853 memristor
xmem854 n56578_57009 n57069_57009 l854 memristor
R855 n56578_57009 n56573_56578 8.5m
xmem856 n56578_57009 n57009_57017 l856 memristor
R857 n25039_25306 n25305_25306 8.5m
xmem858 n25039_25306 n25306_25589 l858 memristor
xmem859 n25039_25306 n24970_25039 l859 memristor
R860 n25039_25306 n25039_26800 8.5m
xmem861 n25305_25306 n25366_25305 l861 memristor
R862 n25305_25306 n24970_25305 8.5m
xmem863 n25305_25306 n25306_25589 l863 memristor
R864 n23673_23682 n23272_23682 8.5m
R865 n23673_23682 n23682_23857 8.5m
R866 n23673_23682 n23673_24902 8.5m
R867 n23272_23682 n23682_23857 8.5m
R868 n13691_14723 n14723_15433 8.5m
xmem869 n13691_14723 n14723_15433 l869 memristor
xmem870 n13691_14723 n13418_13691 l870 memristor
xmem871 n13691_14723 n13418_13691 l871 memristor
xmem872 n14723_15433 n15433_16484 l872 memristor
xmem873 n49091_49315 n49244_49315 l873 memristor
xmem874 n49091_49315 n49016_49315 l874 memristor
xmem875 n49091_49315 n49091_49244 l875 memristor
R876 n49244_49315 n49091_49244 8.5m
R877 n49244_49315 n49016_49315 8.5m
xmem878 n48174_48481 n48481_48698 l878 memristor
xmem879 n48174_48481 n48174_48405 l879 memristor
R880 n48481_48698 n48405_48698 8.5m
R881 n48481_48698 n48698_49505 8.5m
xmem882 n48481_48698 n48174_48481 l882 memristor
xmem883 n29863_30747 n30747_31988 l883 memristor
R884 n29863_30747 n29863_29325 8.5m
xmem885 n29863_30747 n29161_29863 l885 memristor
R886 n29863_30747 n30747_30751 8.5m
xmem887 n30747_31988 n31988_31982 l887 memristor
R888 n30747_31988 n30747_30751 8.5m
R889 n30747_31988 n31988_32344 8.5m
R890 n30868_32232 n32232_32657 8.5m
xmem891 n30868_32232 n30867_30868 l891 memristor
xmem892 n30868_32232 n32232_32233 l892 memristor
xmem893 n30868_32232 n30868_32229 l893 memristor
R894 n32232_32657 n32640_32657 8.5m
R895 n32232_32657 n32657_32903 8.5m
R896 n32232_32657 n32232_32233 8.5m
R897 gnd n46858_47359 8.5m
R898 n59157_59153 n59153_59369 8.5m
R899 n59157_59153 n59110_59157 8.5m
R900 n59157_59153 n59157_59370 8.5m
xmem901 n59157_59153 n59153_59366 l901 memristor
xmem902 n59153_59369 n59153_59366 l902 memristor
R903 n59153_59369 n59366_59369 8.5m
R904 n59153_59369 n59369_59370 8.5m
R905 n52346_52341 n52341_52610 8.5m
R906 n52346_52341 n52346_52613 8.5m
R907 n52346_52341 n52348_52346 8.5m
xmem908 n52341_52610 n52610_53028 l908 memristor
R909 n29174_29576 n29576_29587 8.5m
R910 n29174_29576 n28306_29174 8.5m
R911 n29174_29576 n29576_30140 8.5m
R912 n29174_29576 n29174_29170 8.5m
R913 n29576_29587 n29587_30057 8.5m
xmem914 n29576_29587 n29576_30140 l914 memristor
xmem915 n29576_29587 n29503_29587 l915 memristor
R916 n15538_15691 n16081_15691 8.5m
R917 n15538_15691 n13446_15538 8.5m
R918 n15538_15691 n15691_16001 8.5m
xmem919 n16081_15691 n15691_16001 l919 memristor
xmem920 n16081_15691 n16081_16878 l920 memristor
R921 n41752_42331 n42331_43333 8.5m
R922 n41752_42331 n41752_42274 8.5m
R923 n41752_42331 n42331_42274 8.5m
R924 n41752_42331 n41751_41752 8.5m
R925 n42331_43333 n42331_42274 8.5m
R926 n42331_43333 n43333_44072 8.5m
R927 n42331_43333 n41625_43333 8.5m
R928 n39513_39932 n39932_40521 8.5m
R929 n39513_39932 n37890_39513 8.5m
R930 n39513_39932 n39933_39932 8.5m
xmem931 n39513_39932 n37330_39513 l931 memristor
xmem932 n39932_40521 n39933_39932 l932 memristor
R933 n39932_40521 n40521_40911 8.5m
R934 n39932_40521 n40521_40759 8.5m
xmem935 n22364_22875 n22875_23072 l935 memristor
xmem936 n22364_22875 n22875_22965 l936 memristor
R937 n22364_22875 n22364_22285 8.5m
xmem938 n22364_22875 n21717_22364 l938 memristor
R939 n22875_23072 n22875_22965 8.5m
R940 n22875_23072 n22579_23072 8.5m
xmem941 vin n16721_17171 l941 memristor
R942 n29638_30027 n29289_29638 8.5m
xmem943 n29638_30027 n30027_30177 l943 memristor
xmem944 n29638_30027 n29638_29901 l944 memristor
xmem945 n7578_7962 n7635_7962 l945 memristor
xmem946 n7578_7962 n7113_7578 l946 memristor
xmem947 n7578_7962 n7962_8115 l947 memristor
xmem948 n7578_7962 n7578_7635 l948 memristor
xmem949 n7635_7962 n7578_7635 l949 memristor
xmem950 n7635_7962 n7962_8115 l950 memristor
xmem951 n7635_7962 n7635_7792 l951 memristor
xmem952 n38054_38060 n38060_39437 l952 memristor
R953 n38054_38060 n37596_38060 8.5m
R954 n38054_38060 n38054_38743 8.5m
R955 n38054_38060 n37248_38054 8.5m
R956 n38060_39437 n39437_39787 8.5m
xmem957 n38060_39437 n39003_39437 l957 memristor
xmem958 n38060_39437 n37596_38060 l958 memristor
xmem959 vin n31451_31647 l959 memristor
R960 n37738_38200 n38200_39297 8.5m
R961 n37738_38200 n37738_37936 8.5m
xmem962 n37738_38200 n37626_37738 l962 memristor
xmem963 n38200_39297 n38198_39297 l963 memristor
xmem964 n38200_39297 n39297_39485 l964 memristor
xmem965 n29289_29638 n29638_29901 l965 memristor
xmem966 n29289_29638 n28284_29289 l966 memristor
R967 n29289_29638 n29289_29385 8.5m
R968 n4675_5107 n5107_5394 8.5m
R969 n4675_5107 n4675_4680 8.5m
R970 n4675_5107 n3832_4675 8.5m
R971 n4675_5107 n5104_5107 8.5m
R972 n5107_5394 n5394_5898 8.5m
xmem973 n5107_5394 n5324_5394 l973 memristor
R974 n5107_5394 n5104_5107 8.5m
xmem975 n34119_34379 n34379_34551 l975 memristor
R976 n34119_34379 n34388_34379 8.5m
xmem977 n34119_34379 n33553_34119 l977 memristor
R978 n34119_34379 n34119_33626 8.5m
R979 n34379_34551 n34551_35032 8.5m
R980 n34379_34551 n34551_34622 8.5m
R981 n34379_34551 n34388_34379 8.5m
xmem982 n9329_9653 n9329_9822 l982 memristor
R983 n9329_9653 n8910_9653 8.5m
xmem984 n9329_9653 n9653_10376 l984 memristor
R985 n9329_9653 n8912_9329 8.5m
xmem986 n9329_9822 n8912_9329 l986 memristor
xmem987 n9329_9822 n9582_9822 l987 memristor
xmem988 n9329_9822 n9822_10376 l988 memristor
R989 n15154_15152 n15154_15641 8.5m
xmem990 n15154_15152 n14350_15154 l990 memristor
xmem991 n15154_15152 n15152_15486 l991 memristor
R992 n15154_15641 n14350_15154 8.5m
R993 n15154_15641 n15641_16530 8.5m
xmem994 n15406_15813 n15729_15813 l994 memristor
R995 n15406_15813 n15813_16761 8.5m
xmem996 n15406_15813 n15081_15406 l996 memristor
R997 n15406_15813 n15406_15729 8.5m
R998 n15729_15813 n15729_16108 8.5m
xmem999 n15729_15813 n15406_15729 l999 memristor
R1000 n15729_15813 n15813_16761 8.5m
R1001 n34006_33927 n33927_33931 8.5m
xmem1002 n34006_33927 n34006_34093 l1002 memristor
R1003 n34006_33927 n33259_34006 8.5m
R1004 n34006_33927 n33372_33927 8.5m
R1005 n33927_33931 n33372_33927 8.5m
xmem1006 n33927_33931 n33744_33931 l1006 memristor
xmem1007 n33927_33931 n33614_33931 l1007 memristor
xmem1008 n21155_21445 n21246_21445 l1008 memristor
R1009 n21155_21445 n21155_21945 8.5m
xmem1010 n21155_21445 n21445_21811 l1010 memristor
R1011 n21155_21445 n21155_21246 8.5m
xmem1012 n21246_21445 n21155_21246 l1012 memristor
xmem1013 n21246_21445 n21445_21811 l1013 memristor
R1014 n21246_21445 n21242_21246 8.5m
R1015 vin n17568_17957 8.5m
xmem1016 vin n17171_17568 l1016 memristor
R1017 vin n31451_31647 8.5m
xmem1018 n39068_39593 n39593_39696 l1018 memristor
xmem1019 n39068_39593 n38859_39068 l1019 memristor
R1020 n39068_39593 n39593_39229 8.5m
R1021 n39068_39593 n39068_39229 8.5m
xmem1022 n39593_39696 n39593_39229 l1022 memristor
R1023 n39593_39696 n39696_40822 8.5m
xmem1024 n39593_39696 n39696_39701 l1024 memristor
R1025 n50144_50400 n50400_50458 8.5m
R1026 n50144_50400 n50144_50290 8.5m
xmem1027 n50144_50400 n50400_50335 l1027 memristor
R1028 n50144_50400 n50144_50246 8.5m
R1029 n50400_50458 n50458_50678 8.5m
xmem1030 n50400_50458 n50400_50335 l1030 memristor
R1031 n50400_50458 n50290_50458 8.5m
R1032 n16001_16494 n16494_16863 8.5m
xmem1033 n16001_16494 n16494_16491 l1033 memristor
R1034 n16001_16494 n15607_16001 8.5m
xmem1035 n16001_16494 n15691_16001 l1035 memristor
R1036 n16494_16863 n16863_17182 8.5m
R1037 n16494_16863 n16494_16491 8.5m
xmem1038 n16494_16863 n16878_16863 l1038 memristor
R1039 gnd n52440_52439 8.5m
R1040 vin n9166_9395 8.5m
R1041 vin n33879_34704 8.5m
R1042 vin n33879_34704 8.5m
xmem1043 n9166_9395 n9395_9571 l1043 memristor
xmem1044 n9166_9395 n9395_9815 l1044 memristor
xmem1045 n9395_9571 n9815_9571 l1045 memristor
R1046 n9395_9571 n9571_11021 8.5m
R1047 n9395_9571 n9395_9815 8.5m
xmem1048 n41147_41521 n40533_41147 l1048 memristor
R1049 n1440_1441 n1400_1441 8.5m
R1050 n1440_1441 n1400_1441 8.5m
xmem1051 n1614_1812 n1812_2311 l1051 memristor
xmem1052 n1614_1812 n1812_2311 l1052 memristor
R1053 n1614_1812 n1614_2731 8.5m
R1054 n1614_1812 n606_1614 8.5m
R1055 n1812_2311 n2311_2663 8.5m
R1056 n19434_20496 n20496_20778 8.5m
R1057 n19434_20496 n20496_20497 8.5m
R1058 n19434_20496 n19220_19434 8.5m
xmem1059 n19434_20496 n19140_19434 l1059 memristor
R1060 n20496_20778 n20496_20497 8.5m
R1061 n20496_20778 n20778_21191 8.5m
R1062 n14426_14512 n14512_14992 8.5m
xmem1063 n14426_14512 n14426_14606 l1063 memristor
R1064 n14426_14512 n14610_14512 8.5m
xmem1065 n14426_14512 n14426_14264 l1065 memristor
xmem1066 n14512_14992 n14610_14512 l1066 memristor
R1067 n14512_14992 n14606_14992 8.5m
xmem1068 n14512_14992 n14992_15225 l1068 memristor
R1069 gnd n3534_4047 8.5m
R1070 gnd n4047_4120 8.5m
R1071 gnd n32250_34501 8.5m
R1072 gnd n32250_32913 8.5m
R1073 n47763_47995 n47995_48882 8.5m
R1074 n47763_47995 n47506_47763 8.5m
xmem1075 n47763_47995 n47838_47995 l1075 memristor
R1076 n47763_47995 n47763_47759 8.5m
xmem1077 n47995_48882 n47838_47995 l1077 memristor
xmem1078 n47995_48882 n48882_49203 l1078 memristor
R1079 n47995_48882 n48882_49544 8.5m
R1080 n49435_49359 n49359_49769 8.5m
xmem1081 n49435_49359 n49435_49769 l1081 memristor
R1082 n49435_49359 n49359_49904 8.5m
R1083 n49435_49359 n47639_49435 8.5m
R1084 n49359_49769 n49769_49820 8.5m
xmem1085 n49359_49769 n49359_49904 l1085 memristor
xmem1086 n49359_49769 n49435_49769 l1086 memristor
R1087 n50458_50678 n50339_50678 8.5m
R1088 n50458_50678 n50290_50458 8.5m
xmem1089 n50458_50678 n50678_51702 l1089 memristor
xmem1090 n21083_21739 n21739_22806 l1090 memristor
xmem1091 n21083_21739 n20576_21083 l1091 memristor
R1092 n21083_21739 n21083_20764 8.5m
R1093 n21083_21739 n20981_21739 8.5m
R1094 n21739_22806 n20981_21739 8.5m
R1095 n21739_22806 n22806_23171 8.5m
xmem1096 n21739_22806 n22806_22799 l1096 memristor
R1097 n6351_6338 n6338_6408 8.5m
xmem1098 n6351_6338 n5685_6351 l1098 memristor
xmem1099 n6351_6338 n6338_6671 l1099 memristor
xmem1100 n6351_6338 n6351_6978 l1100 memristor
R1101 n6338_6408 n4095_6408 8.5m
R1102 n6338_6408 n6408_6671 8.5m
R1103 n6338_6408 n6338_6671 8.5m
R1104 n8609_8730 n8730_11268 8.5m
R1105 n8609_8730 n8370_8730 8.5m
R1106 n8609_8730 n8609_9550 8.5m
R1107 n8609_8730 n7884_8609 8.5m
xmem1108 n8730_11268 n11268_12525 l1108 memristor
xmem1109 n8730_11268 n8370_8730 l1109 memristor
R1110 n8730_11268 n11268_12525 8.5m
R1111 n22639_23222 n23222_23520 8.5m
R1112 n22639_23222 n22120_22639 8.5m
R1113 n22639_23222 n23422_23222 8.5m
R1114 n22639_23222 n22542_22639 8.5m
xmem1115 n23222_23520 n23422_23222 l1115 memristor
R1116 n23222_23520 n23429_23520 8.5m
R1117 n23222_23520 n23520_24111 8.5m
xmem1118 n36232_36795 n36795_37700 l1118 memristor
xmem1119 n36232_36795 n36795_37890 l1119 memristor
R1120 n36232_36795 n36232_35773 8.5m
R1121 n36232_36795 n34169_36232 8.5m
xmem1122 n36795_37700 n37700_37896 l1122 memristor
xmem1123 n36795_37700 n37700_37897 l1123 memristor
xmem1124 n36795_37700 n36795_37890 l1124 memristor
R1125 n39030_39263 n39263_39464 8.5m
xmem1126 n39030_39263 n39030_39101 l1126 memristor
R1127 n39030_39263 n39263_39173 8.5m
xmem1128 n39030_39263 n37204_39030 l1128 memristor
R1129 n39263_39464 n39263_39173 8.5m
xmem1130 n39263_39464 n39464_41009 l1130 memristor
R1131 n39263_39464 n39173_39464 8.5m
R1132 n32277_32357 n32200_32357 8.5m
R1133 n32277_32357 n32357_32773 8.5m
R1134 n35032_35928 n35829_35928 8.5m
R1135 n35032_35928 n34551_35032 8.5m
R1136 n35032_35928 n35032_35105 8.5m
R1137 n35032_35928 n35928_36084 8.5m
xmem1138 n35829_35928 n35829_36382 l1138 memristor
xmem1139 n35829_35928 n35928_36084 l1139 memristor
R1140 n35829_35928 n35203_35829 8.5m
xmem1141 n37897_38383 n38383_38739 l1141 memristor
R1142 n37897_38383 n37700_37897 8.5m
R1143 n37897_38383 n38052_38383 8.5m
R1144 n37897_38383 n37897_38052 8.5m
R1145 n38383_38739 n38052_38383 8.5m
xmem1146 n38383_38739 n38743_38739 l1146 memristor
R1147 n38383_38739 n38739_39933 8.5m
R1148 n40771_41926 n41926_42400 8.5m
xmem1149 n40771_41926 n40533_40771 l1149 memristor
xmem1150 n40771_41926 n40771_42058 l1150 memristor
xmem1151 n41926_42400 n42400_42387 l1151 memristor
xmem1152 n41926_42400 n42400_42569 l1152 memristor
R1153 n11532_11690 n11690_12458 8.5m
xmem1154 n11532_11690 n11540_11690 l1154 memristor
R1155 vin n35577_35324 8.5m
R1156 vin n35324_36927 8.5m
xmem1157 n55241_55239 n55241_55486 l1157 memristor
R1158 n55241_55239 n54572_55241 8.5m
R1159 n55241_55239 n55239_55433 8.5m
xmem1160 n55241_55239 n55236_55239 l1160 memristor
xmem1161 n55241_55486 n55486_55826 l1161 memristor
xmem1162 n55241_55486 n55433_55486 l1162 memristor
xmem1163 n55241_55486 n54572_55241 l1163 memristor
R1164 n56566_56909 n56909_56573 8.5m
R1165 n56566_56909 n55144_56566 8.5m
R1166 n56566_56909 n56566_56506 8.5m
R1167 n56566_56909 n56909_57069 8.5m
R1168 n56909_56573 n56909_57069 8.5m
R1169 n56909_56573 n56573_57069 8.5m
R1170 n56909_56573 n56573_56578 8.5m
xmem1171 vin n23895_23966 l1171 memristor
R1172 vin n23895_23631 8.5m
R1173 vin n23046_23895 8.5m
R1174 n2913_2907 n2907_3656 8.5m
R1175 n2913_2907 n1544_2913 8.5m
R1176 n2913_2907 n2913_3508 8.5m
R1177 n2913_2907 n2907_3263 8.5m
R1178 n2907_3656 n3656_3836 8.5m
xmem1179 n2907_3656 n3656_3832 l1179 memristor
xmem1180 n2907_3656 n2907_3263 l1180 memristor
R1181 n19656_21081 n18871_19656 8.5m
R1182 n19656_21081 n19656_19650 8.5m
R1183 n30384_30381 n30381_30641 8.5m
R1184 n30384_30381 n29810_30384 8.5m
xmem1185 n30384_30381 n30375_30381 l1185 memristor
R1186 n30384_30381 n30384_30701 8.5m
xmem1187 n30381_30641 n30375_30381 l1187 memristor
R1188 n30381_30641 n30641_30987 8.5m
R1189 vin n16721_17171 8.5m
R1190 gnd n3534_4047 8.5m
xmem1191 gnd n3476_3534 l1191 memristor
xmem1192 n58338_58391 n58391_58436 l1192 memristor
xmem1193 n58338_58391 n58338_58436 l1193 memristor
xmem1194 n58338_58391 n58344_58338 l1194 memristor
R1195 n58338_58391 n58391_58436 8.5m
xmem1196 n58391_58436 n58338_58436 l1196 memristor
R1197 n35203_35829 n35829_36382 8.5m
R1198 n35203_35829 n34475_35203 8.5m
R1199 n35203_35829 n34559_35203 8.5m
xmem1200 n35829_36382 n38338_36382 l1200 memristor
xmem1201 n35829_36382 n36382_37781 l1201 memristor
xmem1202 n52905_53248 n53248_53423 l1202 memristor
R1203 n52905_53248 n52905_52912 8.5m
R1204 n53248_53423 n53423_53935 8.5m
R1205 n53248_53423 n52905_53248 8.5m
R1206 n53248_53423 n53423_53475 8.5m
R1207 n23837_23456 n23837_24137 8.5m
R1208 n23837_23456 n23456_23458 8.5m
xmem1209 n23837_23456 n22768_23837 l1209 memristor
xmem1210 n23837_23456 n22862_23456 l1210 memristor
xmem1211 n23837_24137 n24137_24414 l1211 memristor
xmem1212 n23837_24137 n22768_23837 l1212 memristor
xmem1213 n23837_24137 n23911_24137 l1213 memristor
R1214 n22451_22556 n22451_22757 8.5m
R1215 n22451_22556 n22556_22851 8.5m
R1216 n22451_22556 n20237_22451 8.5m
xmem1217 n22451_22556 n22556_23828 l1217 memristor
xmem1218 n22451_22757 n20237_22451 l1218 memristor
xmem1219 n22451_22757 n22750_22757 l1219 memristor
xmem1220 n22451_22757 n22757_23823 l1220 memristor
R1221 n51615_52348 n52348_52533 8.5m
R1222 n51615_52348 n51615_52349 8.5m
R1223 n51615_52348 n52348_52346 8.5m
R1224 n51615_52348 n51485_51615 8.5m
xmem1225 n52348_52533 n52348_52346 l1225 memristor
xmem1226 n52348_52533 n52533_52736 l1226 memristor
xmem1227 n52348_52533 n52533_53279 l1227 memristor
R1228 n43819_46255 n46255_46780 8.5m
R1229 n43819_46255 n46255_46484 8.5m
R1230 n43819_46255 n43750_43819 8.5m
xmem1231 n43819_46255 n43819_45008 l1231 memristor
xmem1232 n46255_46780 n46780_47259 l1232 memristor
R1233 n46255_46780 n46255_46484 8.5m
R1234 n46255_46780 n46484_46780 8.5m
R1235 n15813_16761 n16761_17039 8.5m
R1236 n15813_16761 n16761_16269 8.5m
xmem1237 n16761_17039 n16761_16269 l1237 memristor
R1238 n16761_17039 n16970_17039 8.5m
xmem1239 n16761_17039 n17038_17039 l1239 memristor
xmem1240 n5394_5898 n5324_5394 l1240 memristor
R1241 n5394_5898 n5898_7094 8.5m
R1242 n5394_5898 n5476_5898 8.5m
R1243 n16400_16472 n16472_17224 8.5m
R1244 n16400_16472 n15978_16400 8.5m
xmem1245 n16400_16472 n16400_17289 l1245 memristor
R1246 n16400_16472 n16461_16472 8.5m
R1247 n16472_17224 n16461_16472 8.5m
R1248 n16472_17224 n17289_17224 8.5m
R1249 n16472_17224 n16541_17224 8.5m
R1250 vin n12444_12917 8.5m
xmem1251 vin n12367_12444 l1251 memristor
R1252 vin n12444_12917 8.5m
xmem1253 vin n13712_12917 l1253 memristor
R1254 n20925_21298 n21298_21509 8.5m
R1255 n20925_21298 n21298_21676 8.5m
xmem1256 n20925_21298 n19528_20925 l1256 memristor
R1257 n20925_21298 n20925_21403 8.5m
xmem1258 n21298_21509 n21298_21676 l1258 memristor
R1259 n21298_21509 n21403_21509 8.5m
R1260 n21298_21509 n21509_22630 8.5m
R1261 n14074_14000 n14000_14006 8.5m
R1262 n14074_14000 n13523_14074 8.5m
xmem1263 n14074_14000 n14074_14485 l1263 memristor
R1264 n14074_14000 n13524_14000 8.5m
R1265 n14000_14006 n13530_14006 8.5m
xmem1266 n14000_14006 n14006_14079 l1266 memristor
xmem1267 n14000_14006 n13524_14000 l1267 memristor
R1268 n57887_58009 n58009_58140 8.5m
xmem1269 n57887_58009 n57608_57887 l1269 memristor
xmem1270 n57887_58009 n57453_57887 l1270 memristor
R1271 n57887_58009 n58009_58363 8.5m
R1272 n58009_58140 n58082_58140 8.5m
xmem1273 n58009_58140 n58009_58363 l1273 memristor
R1274 n58009_58140 n58140_58363 8.5m
R1275 n13260_13638 n13638_14901 8.5m
R1276 n13260_13638 n13638_13631 8.5m
xmem1277 n13260_13638 n13260_13266 l1277 memristor
R1278 n13260_13638 n12645_13260 8.5m
R1279 n13638_14901 n14597_14901 8.5m
xmem1280 n13638_14901 n14901_15787 l1280 memristor
xmem1281 n13638_14901 n13638_13631 l1281 memristor
R1282 n18421_18419 n18498_18419 8.5m
xmem1283 n18421_18419 n18421_18767 l1283 memristor
xmem1284 n18421_18419 n18119_18419 l1284 memristor
xmem1285 n18421_18419 n17875_18421 l1285 memristor
xmem1286 n18498_18419 n18119_18419 l1286 memristor
R1287 n18498_18419 n18498_18766 8.5m
R1288 n14693_15237 n15237_15804 8.5m
R1289 n14693_15237 n14697_14693 8.5m
R1290 n14693_15237 n15237_17215 8.5m
xmem1291 n14693_15237 n14122_14693 l1291 memristor
xmem1292 n15237_15804 n15231_15804 l1292 memristor
R1293 n15237_15804 n15804_16177 8.5m
R1294 n15237_15804 n15237_17215 8.5m
R1295 n23499_24633 n24633_24629 8.5m
xmem1296 n23499_24633 n24633_24828 l1296 memristor
xmem1297 n23499_24633 n23405_23499 l1297 memristor
R1298 n23499_24633 n23499_24364 8.5m
xmem1299 n24633_24629 n24455_24629 l1299 memristor
R1300 n24633_24629 n24455_24629 8.5m
R1301 n24633_24629 n24633_24828 8.5m
xmem1302 gnd n41798_42079 l1302 memristor
R1303 n15876_16097 n15876_16589 8.5m
R1304 n15876_16097 n15476_15876 8.5m
R1305 n15876_16097 n16097_16580 8.5m
R1306 n15876_16097 n15794_16097 8.5m
R1307 n15876_16589 n16589_16671 8.5m
R1308 n15876_16589 n16589_16580 8.5m
xmem1309 n15876_16589 n15476_15876 l1309 memristor
xmem1310 n43750_43819 n43819_45008 l1310 memristor
xmem1311 n43750_43819 n43119_43750 l1311 memristor
xmem1312 n43750_43819 n43541_43750 l1312 memristor
xmem1313 n43819_45008 n45069_45008 l1313 memristor
R1314 n43819_45008 n45069_45008 8.5m
xmem1315 n22235_22242 n22242_22820 l1315 memristor
R1316 n22235_22242 n20990_22235 8.5m
xmem1317 n22235_22242 n22235_22407 l1317 memristor
xmem1318 n22235_22242 n21003_22242 l1318 memristor
R1319 n22242_22820 n22820_23405 8.5m
xmem1320 n22242_22820 n22820_22421 l1320 memristor
R1321 n22242_22820 n21003_22242 8.5m
R1322 n38268_38618 n38618_40881 8.5m
R1323 n38268_38618 n38102_38268 8.5m
R1324 n38618_40881 n40881_40874 8.5m
R1325 n38618_40881 n38268_38618 8.5m
R1326 n24200_25023 n24876_25023 8.5m
R1327 n24200_25023 n25023_25094 8.5m
xmem1328 n24200_25023 n23058_24200 l1328 memristor
R1329 n24200_25023 n23823_24200 8.5m
xmem1330 n24876_25023 n23829_24876 l1330 memristor
xmem1331 n24876_25023 n23834_24876 l1331 memristor
R1332 n24876_25023 n25023_25094 8.5m
R1333 n19713_20014 n20014_20440 8.5m
xmem1334 n19713_20014 n19093_19713 l1334 memristor
R1335 n19713_20014 n19785_20014 8.5m
xmem1336 n19713_20014 n19713_20340 l1336 memristor
R1337 n20014_20440 n19785_20014 8.5m
R1338 n52508_52509 n52509_52924 8.5m
R1339 n52508_52509 n52139_52508 8.5m
R1340 n52508_52509 n52508_52650 8.5m
xmem1341 n52508_52509 n52251_52509 l1341 memristor
R1342 n52509_52924 n52924_53544 8.5m
R1343 n52509_52924 n52924_54638 8.5m
xmem1344 n52509_52924 n52251_52509 l1344 memristor
xmem1345 n26752_27541 n27541_29284 l1345 memristor
xmem1346 n26752_27541 n26743_26752 l1346 memristor
xmem1347 n26752_27541 n26527_26752 l1347 memristor
R1348 n27541_29284 n29284_29210 8.5m
xmem1349 n27541_29284 n28766_29284 l1349 memristor
xmem1350 n24454_24534 n24448_24534 l1350 memristor
xmem1351 n24454_24534 n24534_25193 l1351 memristor
R1352 n24454_24534 n24454_24455 8.5m
R1353 n24454_24534 n23405_24454 8.5m
R1354 n24448_24534 n24299_24448 8.5m
R1355 n24448_24534 n24448_24991 8.5m
R1356 n24448_24534 n24534_25193 8.5m
xmem1357 n54167_54037 n54037_54043 l1357 memristor
R1358 n54167_54037 n53564_54037 8.5m
xmem1359 n54167_54037 n53196_54167 l1359 memristor
xmem1360 n54167_54037 n54167_54597 l1360 memristor
R1361 n54037_54043 n53564_54037 8.5m
R1362 n54037_54043 n54043_54219 8.5m
R1363 n54037_54043 n53917_54043 8.5m
xmem1364 n50905_51485 n51485_51615 l1364 memristor
R1365 n50905_51485 n50906_50905 8.5m
R1366 n50905_51485 n50715_50905 8.5m
xmem1367 n50905_51485 n51485_51547 l1367 memristor
R1368 n51485_51615 n51615_52349 8.5m
xmem1369 n51485_51615 n51485_51547 l1369 memristor
R1370 vin n22748_23046 8.5m
xmem1371 vin n23046_23895 l1371 memristor
R1372 vin n23135_23046 8.5m
R1373 vin n37626_37738 8.5m
R1374 vin n37626_38198 8.5m
xmem1375 n16400_17289 n17289_17487 l1375 memristor
xmem1376 n16400_17289 n15978_16400 l1376 memristor
R1377 n16400_17289 n17289_17224 8.5m
R1378 n17289_17487 n17487_17935 8.5m
R1379 n17289_17487 n17487_17993 8.5m
xmem1380 n17289_17487 n17289_17224 l1380 memristor
xmem1381 n22308_22814 n22814_23691 l1381 memristor
R1382 n22308_22814 n22308_23103 8.5m
R1383 n22308_22814 n22102_22308 8.5m
R1384 n22308_22814 n22814_23103 8.5m
R1385 n22814_23691 n23691_23687 8.5m
xmem1386 n22814_23691 n22814_23103 l1386 memristor
R1387 n22814_23691 n23691_24528 8.5m
R1388 n31570_31715 n31715_32911 8.5m
R1389 n31570_31715 n31570_32911 8.5m
R1390 n31715_32911 n32911_32913 8.5m
R1391 n31715_32911 n31570_32911 8.5m
R1392 n31715_32911 n31570_31715 8.5m
R1393 n12054_12458 n12458_12778 8.5m
R1394 n12054_12458 n12054_13076 8.5m
R1395 n12054_12458 n11690_12458 8.5m
xmem1396 n12458_12778 n12778_13524 l1396 memristor
R1397 n12458_12778 n12781_12778 8.5m
R1398 n12458_12778 n11690_12458 8.5m
xmem1399 n13418_13691 n12525_13418 l1399 memristor
xmem1400 n13418_13691 n12525_13418 l1400 memristor
xmem1401 n48942_50246 n50144_50246 l1401 memristor
xmem1402 n48942_50246 n50246_50335 l1402 memristor
R1403 n48942_50246 n48272_48942 8.5m
R1404 n48942_50246 n48272_48942 8.5m
xmem1405 n50144_50246 n50144_50290 l1405 memristor
xmem1406 n50144_50246 n50246_50335 l1406 memristor
xmem1407 n11404_11839 n11585_11839 l1407 memristor
xmem1408 n11404_11839 n11404_11585 l1408 memristor
R1409 n11404_11839 n11184_11404 8.5m
xmem1410 n11585_11839 n11404_11585 l1410 memristor
xmem1411 n11585_11839 n11184_11585 l1411 memristor
R1412 n45996_46463 n45995_45996 8.5m
R1413 n45996_46463 n45996_46619 8.5m
xmem1414 n46663_47137 n47137_47217 l1414 memristor
R1415 n46663_47137 n47137_47875 8.5m
xmem1416 n46663_47137 n46319_46663 l1416 memristor
xmem1417 n46663_47137 n46663_46794 l1417 memristor
R1418 n47137_47217 n47217_48035 8.5m
R1419 n47137_47217 n47137_47875 8.5m
xmem1420 n47137_47217 n47079_47217 l1420 memristor
R1421 n32848_32849 n32849_33516 8.5m
xmem1422 n32848_32849 n32848_33352 l1422 memristor
R1423 n32848_32849 n31818_32848 8.5m
R1424 n32848_32849 n32272_32849 8.5m
xmem1425 n32849_33516 n33516_34068 l1425 memristor
xmem1426 n32849_33516 n33516_34164 l1426 memristor
xmem1427 n32849_33516 n32272_32849 l1427 memristor
R1428 n24653_24750 n21191_24653 8.5m
xmem1429 n24653_24750 n24653_24312 l1429 memristor
R1430 n25622_25623 n25623_26059 8.5m
R1431 n25622_25623 n25623_25966 8.5m
R1432 n25622_25623 n25622_26059 8.5m
R1433 n25622_25623 n25265_25622 8.5m
xmem1434 n25623_26059 n25622_26059 l1434 memristor
xmem1435 n25623_26059 n25623_25966 l1435 memristor
xmem1436 n25623_26059 n26059_26420 l1436 memristor
R1437 n22691_22584 n22691_24593 8.5m
xmem1438 n22691_22584 n22374_22584 l1438 memristor
xmem1439 n22691_22584 n21954_22691 l1439 memristor
R1440 n22691_22584 n22374_22584 8.5m
R1441 n22691_24593 n24593_25310 8.5m
R1442 n22691_24593 n24593_23920 8.5m
R1443 n22691_24593 n21954_22691 8.5m
R1444 n23966_24040 n23895_23966 8.5m
R1445 n34855_35080 n34855_35272 8.5m
R1446 n34855_35080 n35080_37248 8.5m
R1447 n34855_35272 n35272_35436 8.5m
xmem1448 n34855_35272 n35006_35272 l1448 memristor
xmem1449 n34855_35272 n34855_35080 l1449 memristor
R1450 n35665_36164 n35665_36476 8.5m
R1451 n35665_36164 n36164_36475 8.5m
R1452 n35665_36164 n33310_36164 8.5m
R1453 n35665_36164 n35139_35665 8.5m
xmem1454 n35665_36476 n36476_36621 l1454 memristor
R1455 n35665_36476 n35139_35665 8.5m
R1456 n35665_36476 n36476_36621 8.5m
R1457 n34475_35203 n33478_34475 8.5m
R1458 n34475_35203 n34475_34559 8.5m
R1459 n34475_35203 n34559_35203 8.5m
xmem1460 n16761_16269 n16108_16269 l1460 memristor
R1461 n16761_16269 n16269_16970 8.5m
xmem1462 n38052_38383 n37897_38052 l1462 memristor
R1463 n38052_38383 n37896_38052 8.5m
R1464 n7528_8400 n8400_8316 8.5m
R1465 n7528_8400 n8400_8910 8.5m
xmem1466 n7528_8400 n7299_7528 l1466 memristor
xmem1467 n7528_8400 n7528_7599 l1467 memristor
xmem1468 n8400_8316 n8400_8910 l1468 memristor
R1469 n8400_8316 n7599_8316 8.5m
xmem1470 n8400_8316 n8316_8912 l1470 memristor
xmem1471 n53084_53341 n53341_53514 l1471 memristor
xmem1472 n53084_53341 n53028_53341 l1472 memristor
xmem1473 n53084_53341 n52807_53084 l1473 memristor
xmem1474 n53084_53341 n53086_53084 l1474 memristor
R1475 n53341_53514 n53917_53514 8.5m
xmem1476 n53341_53514 n53028_53341 l1476 memristor
R1477 n53341_53514 n53275_53514 8.5m
R1478 n14723_15433 n15433_16484 8.5m
xmem1479 n10177_10173 n10173_12725 l1479 memristor
R1480 n10177_10173 n8923_10177 8.5m
xmem1481 n10177_10173 n10177_10789 l1481 memristor
xmem1482 n10177_10173 n9426_10173 l1482 memristor
R1483 n10173_12725 n12725_13647 8.5m
xmem1484 n10173_12725 n9426_10173 l1484 memristor
R1485 n10173_12725 n9426_12725 8.5m
R1486 n7823_9582 n9582_9822 8.5m
xmem1487 n7823_9582 n9582_10569 l1487 memristor
R1488 n7129_7446 n7446_7441 8.5m
xmem1489 n7129_7446 n7129_7441 l1489 memristor
xmem1490 n7129_7446 n7129_7436 l1490 memristor
xmem1491 n7446_7441 n7436_7441 l1491 memristor
xmem1492 n7446_7441 n7129_7441 l1492 memristor
R1493 n22374_22584 n22371_22374 8.5m
xmem1494 n47217_48035 n48035_48031 l1494 memristor
xmem1495 n47217_48035 n48035_48923 l1495 memristor
xmem1496 n47217_48035 n47079_47217 l1496 memristor
R1497 n48035_48031 n48035_48923 8.5m
R1498 n48035_48031 n47875_48031 8.5m
R1499 n48035_48031 n48031_48708 8.5m
R1500 n20223_20936 n20936_21310 8.5m
R1501 n20223_20936 n20223_21310 8.5m
xmem1502 n20223_20936 n20936_21034 l1502 memristor
xmem1503 n20936_21310 n21310_21696 l1503 memristor
R1504 n20936_21310 n20223_21310 8.5m
xmem1505 n20936_21310 n20936_21034 l1505 memristor
R1506 n27443_27729 n27729_27936 8.5m
R1507 n27443_27729 n26275_27443 8.5m
R1508 n27443_27729 n27729_27856 8.5m
xmem1509 n27443_27729 n27443_26994 l1509 memristor
R1510 n27729_27936 n27936_27856 8.5m
R1511 n27729_27936 n27729_27856 8.5m
R1512 n27729_27936 n28009_27936 8.5m
R1513 vin n12444_12917 8.5m
xmem1514 vin n12367_12444 l1514 memristor
R1515 n30751_31169 n31248_31169 8.5m
xmem1516 n30751_31169 n30559_30751 l1516 memristor
R1517 n30751_31169 n30747_30751 8.5m
xmem1518 n30751_31169 n31169_31663 l1518 memristor
xmem1519 n31248_31169 n31169_31663 l1519 memristor
xmem1520 n31248_31169 n31248_31733 l1520 memristor
R1521 n31248_31169 n30624_31248 8.5m
R1522 n37205_39104 n39104_39101 8.5m
xmem1523 n37205_39104 n36453_37205 l1523 memristor
R1524 n37205_39104 n39104_39629 8.5m
xmem1525 n37205_39104 n36747_37205 l1525 memristor
xmem1526 n39104_39101 n39104_39629 l1526 memristor
R1527 n39104_39101 n39030_39101 8.5m
R1528 n39104_39101 n39101_39629 8.5m
R1529 vin n137_223 8.5m
R1530 vin n223_234 8.5m
R1531 n26275_27443 n27443_26994 8.5m
R1532 n26275_27443 n26275_26803 8.5m
R1533 n26275_27443 n26276_26275 8.5m
R1534 n24837_25794 n25794_26653 8.5m
R1535 n24837_25794 n25794_25887 8.5m
xmem1536 n24837_25794 n24837_24828 l1536 memristor
R1537 n24837_25794 n24364_24837 8.5m
xmem1538 n25794_26653 n26653_26527 l1538 memristor
R1539 n25794_26653 n25794_25887 8.5m
xmem1540 n25794_26653 n26653_27386 l1540 memristor
R1541 n23542_23631 n23895_23631 8.5m
xmem1542 n23542_23631 n23058_23542 l1542 memristor
R1543 n23542_23631 n23135_23631 8.5m
R1544 n52073_52301 n52301_52295 8.5m
xmem1545 n52073_52301 n52301_52449 l1545 memristor
R1546 n52073_52301 n52073_52295 8.5m
xmem1547 n52073_52301 n52067_52073 l1547 memristor
xmem1548 n52301_52295 n52073_52295 l1548 memristor
R1549 n52301_52295 n52301_52449 8.5m
R1550 n52301_52295 n52295_52771 8.5m
R1551 n8129_7432 n8063_7432 8.5m
R1552 n8129_7432 n4192_7432 8.5m
R1553 n8129_7432 n8129_8619 8.5m
R1554 n8063_7432 n4192_7432 8.5m
xmem1555 n8063_7432 n8063_8619 l1555 memristor
R1556 n8063_7432 n4867_8063 8.5m
R1557 n30559_30751 n30559_30624 8.5m
R1558 n30559_30751 n30747_30751 8.5m
R1559 n30559_30751 n30140_30559 8.5m
R1560 n20495_21011 n21011_21983 8.5m
R1561 n20495_21011 n21011_21191 8.5m
R1562 n20495_21011 n19208_20495 8.5m
R1563 n20495_21011 n20495_20376 8.5m
xmem1564 n21011_21983 n21011_21191 l1564 memristor
R1565 n21011_21983 n21983_26312 8.5m
R1566 n21011_21983 n21666_21983 8.5m
R1567 n8400_8910 n8912_8910 8.5m
xmem1568 n8400_8910 n8910_9653 l1568 memristor
R1569 n33437_33976 n33976_35260 8.5m
xmem1570 n33437_33976 n33339_33437 l1570 memristor
R1571 n33437_33976 n33346_33437 8.5m
R1572 n33437_33976 n33971_33976 8.5m
xmem1573 n33976_35260 n33971_33976 l1573 memristor
R1574 n33976_35260 n34160_35260 8.5m
xmem1575 n33976_35260 n35260_35767 l1575 memristor
R1576 n12642_12645 n12642_13631 8.5m
R1577 n12642_12645 n12645_13260 8.5m
xmem1578 n12642_12645 n12645_12870 l1578 memristor
R1579 n12642_12645 n11296_12642 8.5m
xmem1580 n12642_13631 n13638_13631 l1580 memristor
xmem1581 n12642_13631 n13631_14597 l1581 memristor
R1582 n12642_13631 n11296_12642 8.5m
R1583 n21039_21230 n20521_21039 8.5m
R1584 n21039_21230 n20521_21230 8.5m
R1585 n21039_21230 n20521_21230 8.5m
R1586 n21039_21230 n20521_21039 8.5m
R1587 n45329_45799 n45799_45805 8.5m
R1588 n45329_45799 n45799_46152 8.5m
R1589 n45329_45799 n45329_46148 8.5m
xmem1590 n45329_45799 n45069_45329 l1590 memristor
R1591 n45799_45805 n45734_45805 8.5m
R1592 n45799_45805 n45799_46152 8.5m
xmem1593 n45799_45805 n45805_46787 l1593 memristor
xmem1594 n32844_33336 n33339_33336 l1594 memristor
R1595 n32844_33336 n33336_33971 8.5m
xmem1596 n32844_33336 n32761_32844 l1596 memristor
R1597 n32844_33336 n32844_33339 8.5m
R1598 n33339_33336 n32844_33339 8.5m
R1599 n33339_33336 n33339_33437 8.5m
xmem1600 n33339_33336 n33336_33971 l1600 memristor
xmem1601 n11349_11857 n11349_11517 l1601 memristor
R1602 n11349_11857 n11853_11857 8.5m
R1603 n11349_11857 n10451_11349 8.5m
R1604 n11349_11517 n10451_11349 8.5m
R1605 n2274_3730 n3561_3730 8.5m
xmem1606 n2274_3730 n2115_2274 l1606 memristor
R1607 n2274_3730 n2115_2274 8.5m
R1608 n8482_8841 n8841_9337 8.5m
xmem1609 n8482_8841 n8841_8773 l1609 memristor
R1610 n8482_8841 n5447_8482 8.5m
R1611 n8841_9337 n8773_9337 8.5m
xmem1612 n8841_9337 n9337_9414 l1612 memristor
R1613 n8841_9337 n8841_8773 8.5m
xmem1614 n36207_36656 n36656_37204 l1614 memristor
R1615 n36207_36656 n34220_36207 8.5m
R1616 n36207_36656 n36656_36743 8.5m
R1617 n36656_37204 n36743_37204 8.5m
xmem1618 n36656_37204 n37204_39030 l1618 memristor
R1619 n36656_37204 n36656_36743 8.5m
R1620 n26671_26950 n26950_27311 8.5m
R1621 n26671_26950 n26066_26671 8.5m
R1622 n26671_26950 n26671_27311 8.5m
xmem1623 n26671_26950 n26950_27059 l1623 memristor
R1624 n26950_27311 n26950_27059 8.5m
xmem1625 n26950_27311 n26671_27311 l1625 memristor
R1626 n26950_27311 n27311_27479 8.5m
xmem1627 n55144_56566 n54740_55144 l1627 memristor
R1628 n55144_56566 n55144_56506 8.5m
xmem1629 n55144_56566 n56566_56506 l1629 memristor
R1630 n44679_45200 n45200_45482 8.5m
R1631 n44679_45200 n44679_44835 8.5m
xmem1632 n44679_45200 n42541_44679 l1632 memristor
xmem1633 n44679_45200 n45200_45198 l1633 memristor
R1634 n45200_45482 n45482_45973 8.5m
xmem1635 n45200_45482 n45271_45482 l1635 memristor
xmem1636 n45200_45482 n45200_45198 l1636 memristor
R1637 n27998_29424 n29503_29424 8.5m
R1638 n27998_29424 n29424_29806 8.5m
xmem1639 n27998_29424 n27998_28242 l1639 memristor
R1640 n27998_29424 n27603_27998 8.5m
R1641 n29503_29424 n29503_29587 8.5m
R1642 n29503_29424 n28306_29503 8.5m
R1643 n29503_29424 n29424_29806 8.5m
xmem1644 n19785_19479 n19785_20014 l1644 memristor
xmem1645 n19785_19479 n19245_19479 l1645 memristor
R1646 n19785_19479 n19479_21452 8.5m
R1647 n19785_19479 n19093_19785 8.5m
R1648 n19785_20014 n19093_19785 8.5m
xmem1649 n54788_55154 n54477_55154 l1649 memristor
R1650 n54788_55154 n54869_55154 8.5m
R1651 n54788_55154 n54189_54788 8.5m
R1652 n54477_55154 n54052_54477 8.5m
R1653 n54477_55154 n54474_54477 8.5m
xmem1654 n54477_55154 n54869_55154 l1654 memristor
xmem1655 n43373_43142 n43142_43777 l1655 memristor
xmem1656 n43373_43142 n40327_43142 l1656 memristor
R1657 n43373_43142 n43373_43709 8.5m
xmem1658 n43373_43142 n43373_43777 l1658 memristor
xmem1659 n43142_43777 n40327_43142 l1659 memristor
R1660 n43142_43777 n43777_43843 8.5m
R1661 n43142_43777 n43373_43777 8.5m
xmem1662 vin n137_223 l1662 memristor
R1663 n1812_2311 n2311_2663 8.5m
xmem1664 n40208_40575 n40575_41316 l1664 memristor
xmem1665 n40208_40575 n39841_40208 l1665 memristor
R1666 n40575_41316 n40208_40575 8.5m
R1667 n40575_41316 n41316_42037 8.5m
R1668 n40575_41316 n41316_42371 8.5m
R1669 n23103_23105 n23400_23105 8.5m
xmem1670 n23103_23105 n22308_23103 l1670 memristor
R1671 n23103_23105 n22403_23105 8.5m
R1672 n23103_23105 n22814_23103 8.5m
xmem1673 n23400_23105 n23400_23700 l1673 memristor
xmem1674 n23400_23105 n22325_23400 l1674 memristor
R1675 n23400_23105 n22403_23105 8.5m
R1676 n36414_37079 n37079_37396 8.5m
xmem1677 n36414_37079 n35506_36414 l1677 memristor
R1678 n37079_37396 n36414_37079 8.5m
R1679 n37079_37396 n37396_38859 8.5m
xmem1680 n37079_37396 n37396_37399 l1680 memristor
R1681 n52974_53153 n52816_53153 8.5m
xmem1682 n52974_53153 n52433_52974 l1682 memristor
R1683 n52974_53153 n52974_52816 8.5m
xmem1684 n52816_53153 n52439_52816 l1684 memristor
xmem1685 n52816_53153 n52974_52816 l1685 memristor
R1686 n22120_22639 n22542_22639 8.5m
R1687 n22120_22639 n21790_22120 8.5m
xmem1688 n22120_22639 n22120_22542 l1688 memristor
xmem1689 n38921_38990 n38990_39422 l1689 memristor
R1690 n38921_38990 n38921_39325 8.5m
xmem1691 n38921_38990 n38293_38921 l1691 memristor
xmem1692 n38921_38990 n38719_38990 l1692 memristor
xmem1693 n38990_39422 n38719_38990 l1693 memristor
xmem1694 n38990_39422 n39422_39768 l1694 memristor
R1695 n38990_39422 n39422_39325 8.5m
xmem1696 n28215_28355 n28417_28355 l1696 memristor
R1697 n28215_28355 n28352_28355 8.5m
R1698 n28215_28355 n28052_28215 8.5m
R1699 n28215_28355 n28215_28057 8.5m
R1700 n28417_28355 n28352_28355 8.5m
R1701 n28417_28355 n28057_28417 8.5m
R1702 n28417_28355 n28057_28417 8.5m
R1703 n10720_11056 n11056_11054 8.5m
R1704 n10720_11056 n10327_10720 8.5m
xmem1705 n10720_11056 n10720_11317 l1705 memristor
R1706 n10720_11056 n11056_11313 8.5m
xmem1707 n11056_11054 n10881_11054 l1707 memristor
R1708 n11056_11054 n10881_11054 8.5m
xmem1709 n11056_11054 n11056_11313 l1709 memristor
R1710 n15862_16158 n16158_16574 8.5m
xmem1711 n15862_16158 n16014_15862 l1711 memristor
xmem1712 n15862_16158 n14594_15862 l1712 memristor
R1713 n15862_16158 n16158_16153 8.5m
xmem1714 n16158_16574 n16153_16574 l1714 memristor
xmem1715 n16158_16574 n16574_17859 l1715 memristor
R1716 n16158_16574 n16158_16153 8.5m
xmem1717 n48955_49266 n49266_49616 l1717 memristor
xmem1718 n48955_49266 n49266_49548 l1718 memristor
xmem1719 n48955_49266 n48955_49138 l1719 memristor
xmem1720 n48955_49266 n47838_48955 l1720 memristor
R1721 n49266_49616 n49266_49548 8.5m
xmem1722 n49266_49616 n49616_49811 l1722 memristor
R1723 n49266_49616 n49548_49616 8.5m
xmem1724 n31289_31277 n31277_31841 l1724 memristor
R1725 n31289_31277 n31289_31426 8.5m
xmem1726 n31289_31277 n31130_31289 l1726 memristor
xmem1727 n31289_31277 n31130_31277 l1727 memristor
xmem1728 n31277_31841 n31841_33609 l1728 memristor
R1729 n31277_31841 n31841_31930 8.5m
R1730 n31277_31841 n31130_31277 8.5m
R1731 gnd n34501_34571 8.5m
R1732 gnd n32250_34501 8.5m
R1733 n29961_30186 n30186_30300 8.5m
xmem1734 n29961_30186 n30186_32923 l1734 memristor
R1735 n29961_30186 n29961_30300 8.5m
R1736 n30186_30300 n29961_30300 8.5m
R1737 n30186_30300 n30186_32923 8.5m
R1738 n13523_13524 n13524_14000 8.5m
xmem1739 n13523_13524 n13523_14074 l1739 memristor
R1740 n13523_13524 n13076_13523 8.5m
R1741 n13523_13524 n12778_13524 8.5m
R1742 n13524_14000 n12778_13524 8.5m
R1743 n28052_28215 n28052_28352 8.5m
xmem1744 n28052_28215 n28215_28057 l1744 memristor
R1745 n28052_28215 n27564_28052 8.5m
R1746 n28052_28352 n28352_28355 8.5m
xmem1747 n28052_28352 n27564_28052 l1747 memristor
R1748 n36084_38338 n38338_38341 8.5m
xmem1749 n36084_38338 n35928_36084 l1749 memristor
R1750 n36084_38338 n38338_36382 8.5m
R1751 n36084_38338 n36084_36380 8.5m
xmem1752 n38338_38341 n38338_36382 l1752 memristor
xmem1753 n38338_38341 n37781_38341 l1753 memristor
xmem1754 n38338_38341 n38341_38484 l1754 memristor
xmem1755 n7096_8587 n8587_8863 l1755 memristor
R1756 n7096_8587 n8587_8799 8.5m
R1757 n7096_8587 n7094_7096 8.5m
R1758 n7096_8587 n7032_7096 8.5m
R1759 n8587_8863 n8587_8799 8.5m
xmem1760 n29188_29351 n29351_30157 l1760 memristor
R1761 n29188_29351 n29351_30076 8.5m
xmem1762 n29188_29351 n28256_29188 l1762 memristor
xmem1763 n29188_29351 n29188_28910 l1763 memristor
xmem1764 n29351_30157 n30157_30995 l1764 memristor
xmem1765 n29351_30157 n29351_30076 l1765 memristor
R1766 n29351_30157 n30076_30157 8.5m
xmem1767 n4279_5447 n3974_5447 l1767 memristor
R1768 n4279_5447 n5447_8482 8.5m
R1769 n4279_5447 n2663_4279 8.5m
R1770 n4279_5447 n3304_4279 8.5m
xmem1771 n3974_5447 n3625_3974 l1771 memristor
R1772 n3974_5447 n3625_3974 8.5m
xmem1773 n3974_5447 n5447_8482 l1773 memristor
R1774 n4675_4680 n4680_4812 8.5m
R1775 n4675_4680 n3832_4675 8.5m
xmem1776 n4675_4680 n4372_4680 l1776 memristor
R1777 n4680_4812 n4372_4680 8.5m
xmem1778 n4680_4812 n4818_4812 l1778 memristor
R1779 n4680_4812 n4812_5324 8.5m
R1780 n43573_43656 n43656_44202 8.5m
R1781 n43573_43656 n43570_43573 8.5m
R1782 n37626_38198 n38198_39297 8.5m
xmem1783 n37626_38198 n37626_37738 l1783 memristor
R1784 n9426_12725 n12725_13647 8.5m
R1785 n9426_12725 n9426_8776 8.5m
R1786 n9426_12725 n9426_10173 8.5m
xmem1787 n12725_13647 n13647_13930 l1787 memristor
R1788 n12725_13647 n13647_14102 8.5m
R1789 n23456_23458 n22862_23456 8.5m
xmem1790 n23456_23458 n22965_23458 l1790 memristor
xmem1791 n23456_23458 n23458_23911 l1791 memristor
R1792 n8953_9461 n9461_10521 8.5m
xmem1793 n8953_9461 n8033_8953 l1793 memristor
R1794 n8953_9461 n8953_9948 8.5m
R1795 n8953_9461 n9461_9456 8.5m
R1796 n9461_10521 n10521_10620 8.5m
xmem1797 n9461_10521 n10521_10628 l1797 memristor
xmem1798 n9461_10521 n9461_9456 l1798 memristor
R1799 n26287_27112 n27118_27112 8.5m
xmem1800 n26287_27112 n26287_27118 l1800 memristor
xmem1801 n27118_27112 n27118_27672 l1801 memristor
R1802 n27118_27112 n26287_27112 8.5m
R1803 n27118_27112 n26287_27118 8.5m
xmem1804 n56909_57069 n57069_57009 l1804 memristor
R1805 n56909_57069 n56573_57069 8.5m
xmem1806 n57069_57009 n57009_57017 l1806 memristor
R1807 n57069_57009 n56573_57069 8.5m
xmem1808 n12376_12379 n12379_12854 l1808 memristor
xmem1809 n12376_12379 n11885_12379 l1809 memristor
xmem1810 n12376_12379 n12376_13244 l1810 memristor
R1811 n12376_12379 n11882_12376 8.5m
R1812 n12379_12854 n12854_13011 8.5m
R1813 n12379_12854 n12854_13152 8.5m
R1814 n12379_12854 n11885_12379 8.5m
R1815 n7578_7635 n7635_7792 8.5m
R1816 n7578_7635 n7113_7578 8.5m
R1817 n7635_7792 n7792_8115 8.5m
R1818 n7635_7792 n7792_8116 8.5m
R1819 n59111_59322 n59374_59322 8.5m
R1820 n59111_59322 n59111_59110 8.5m
R1821 n59374_59322 n59110_59374 8.5m
R1822 n59374_59322 n59374_59370 8.5m
R1823 n59374_59322 n59111_59322 8.5m
R1824 n23711_24648 n23711_24241 8.5m
R1825 n23711_24648 n22924_23711 8.5m
R1826 n23711_24648 n24648_24637 8.5m
R1827 gnd n2598_2893 8.5m
R1828 n7844_7165 n7844_8230 8.5m
R1829 n7844_7165 n7165_8329 8.5m
R1830 n7844_7165 n6307_7165 8.5m
xmem1831 n7844_7165 n6545_7844 l1831 memristor
R1832 n7844_8230 n8329_8230 8.5m
xmem1833 n7844_8230 n6545_7844 l1833 memristor
R1834 n7844_8230 n8238_8230 8.5m
xmem1835 n44053_44060 n44060_44528 l1835 memristor
xmem1836 n44053_44060 n44060_44655 l1836 memristor
R1837 n44053_44060 n44053_44052 8.5m
xmem1838 n44053_44060 n42274_44053 l1838 memristor
R1839 n44060_44528 n44072_44528 8.5m
xmem1840 n44060_44528 n44060_44655 l1840 memristor
xmem1841 n44060_44528 n44528_44531 l1841 memristor
R1842 n52562_52650 n52650_53007 8.5m
R1843 n52562_52650 n52508_52650 8.5m
R1844 n52562_52650 n52562_53645 8.5m
R1845 n52562_52650 n52562_53003 8.5m
R1846 n52650_53007 n53007_53599 8.5m
xmem1847 n52650_53007 n52508_52650 l1847 memristor
R1848 n52650_53007 n53003_53007 8.5m
R1849 n26743_26917 n26823_26917 8.5m
xmem1850 n26743_26917 n26743_26752 l1850 memristor
R1851 n26743_26917 n26917_27536 8.5m
R1852 n26743_26917 n25613_26743 8.5m
R1853 n26823_26917 n26823_26398 8.5m
xmem1854 n26823_26917 n26917_27536 l1854 memristor
xmem1855 n26823_26917 n25881_26823 l1855 memristor
xmem1856 gnd n2598_2893 l1856 memristor
R1857 n31258_31668 n31668_32272 8.5m
xmem1858 n31258_31668 n31093_31258 l1858 memristor
R1859 n31258_31668 n31094_31258 8.5m
R1860 n31258_31668 n31668_31818 8.5m
R1861 n31668_32272 n32272_32849 8.5m
R1862 n31668_32272 n31668_31818 8.5m
R1863 n55230_55683 n55683_56063 8.5m
xmem1864 n55230_55683 n55683_55677 l1864 memristor
R1865 n55900_56359 n56359_55987 8.5m
R1866 n55900_56359 n56359_56523 8.5m
xmem1867 n55900_56359 n55900_55987 l1867 memristor
R1868 n55900_56359 n55827_55900 8.5m
R1869 n56359_55987 n55900_55987 8.5m
xmem1870 n56359_55987 n55987_56418 l1870 memristor
xmem1871 n56359_55987 n56359_56523 l1871 memristor
R1872 n22308_23103 n22814_23103 8.5m
xmem1873 n22308_23103 n22102_22308 l1873 memristor
R1874 n2907_3263 n3263_3657 8.5m
R1875 n2907_3263 n3263_3505 8.5m
R1876 n3263_3657 n3657_3662 8.5m
xmem1877 n3263_3657 n3657_3758 l1877 memristor
R1878 n3263_3657 n3263_3505 8.5m
R1879 n27443_26994 n26994_27365 8.5m
xmem1880 n27443_26994 n26803_26994 l1880 memristor
R1881 n58019_58482 n58378_58482 8.5m
xmem1882 n58019_58482 n57847_58019 l1882 memristor
R1883 n58019_58482 n58019_58255 8.5m
R1884 n58019_58482 n58378_58482 8.5m
R1885 n58378_58482 n58255_58378 8.5m
R1886 n26234_26863 n26863_27081 8.5m
R1887 n26234_26863 n26234_26697 8.5m
xmem1888 n26234_26863 n25094_26234 l1888 memristor
R1889 n26234_26863 n26697_26863 8.5m
R1890 n26863_27081 n26697_26863 8.5m
R1891 n26863_27081 n25094_27081 8.5m
xmem1892 n26863_27081 n26697_27081 l1892 memristor
R1893 n21973_23095 n23095_23378 8.5m
xmem1894 n21973_23095 n21747_21973 l1894 memristor
R1895 n21973_23095 n21747_21973 8.5m
R1896 n21973_23095 n23095_23687 8.5m
xmem1897 n23095_23378 n23377_23378 l1897 memristor
R1898 n23095_23378 n23095_23687 8.5m
xmem1899 n23095_23378 n23378_24077 l1899 memristor
R1900 n57847_58019 n58019_58255 8.5m
R1901 n57847_58019 n57620_57847 8.5m
xmem1902 n57847_58019 n57620_57847 l1902 memristor
xmem1903 n58019_58255 n58255_58378 l1903 memristor
R1904 n39128_39664 n39664_39661 8.5m
R1905 n39128_39664 n39128_39316 8.5m
R1906 n39128_39664 n38500_39128 8.5m
R1907 n39128_39664 n39664_39910 8.5m
R1908 n39664_39661 n39664_39910 8.5m
R1909 n39664_39661 n39661_40203 8.5m
R1910 n39664_39661 n39562_39661 8.5m
R1911 n17794_17799 n17799_18236 8.5m
R1912 n17794_17799 n17467_17799 8.5m
R1913 n17794_17799 n17329_17794 8.5m
R1914 n17794_17799 n17794_17865 8.5m
R1915 n17799_18236 n18236_18405 8.5m
xmem1916 n17799_18236 n17865_18236 l1916 memristor
R1917 n17799_18236 n17467_17799 8.5m
R1918 n22748_23046 n23135_23046 8.5m
R1919 n22748_23046 n22548_22748 8.5m
R1920 n22748_23046 n23046_23895 8.5m
R1921 n26716_27099 n27099_27792 8.5m
R1922 n26716_27099 n26716_26803 8.5m
R1923 n26716_27099 n27099_27349 8.5m
R1924 n26716_27099 n25310_26716 8.5m
R1925 n27099_27792 n27099_27349 8.5m
R1926 n27099_27792 n26800_27792 8.5m
R1927 n27099_27792 n27792_27930 8.5m
R1928 n3836_3758 n3836_4372 8.5m
xmem1929 n3836_3758 n3657_3758 l1929 memristor
R1930 n3836_3758 n3758_3918 8.5m
xmem1931 n3836_3758 n3656_3836 l1931 memristor
R1932 n3836_4372 n3656_3836 8.5m
R1933 n3836_4372 n4372_4818 8.5m
xmem1934 n3836_4372 n4372_4680 l1934 memristor
xmem1935 n16461_16541 n16840_16541 l1935 memristor
R1936 n16461_16541 n16461_16472 8.5m
xmem1937 n16461_16541 n16280_16461 l1937 memristor
R1938 n16461_16541 n16541_17224 8.5m
xmem1939 n16840_16541 n16460_16840 l1939 memristor
xmem1940 n16840_16541 n16840_18050 l1940 memristor
xmem1941 n16840_16541 n16541_17224 l1941 memristor
R1942 n11882_12376 n12376_13244 8.5m
xmem1943 n11882_12376 n11788_11882 l1943 memristor
R1944 n11882_12376 n11878_11882 8.5m
R1945 n12376_13244 n13244_13152 8.5m
R1946 n12376_13244 n13244_13623 8.5m
R1947 n36164_36475 n36475_37291 8.5m
R1948 n36164_36475 n36475_37145 8.5m
R1949 n36164_36475 n33310_36164 8.5m
xmem1950 n50144_50290 n50290_50458 l1950 memristor
R1951 n50144_50290 n50290_50339 8.5m
R1952 n50290_50458 n50290_50339 8.5m
xmem1953 n15450_15535 n15535_16302 l1953 memristor
R1954 n15450_15535 n15444_15450 8.5m
xmem1955 n15450_15535 n15535_16302 l1955 memristor
R1956 n15450_15535 n15444_15450 8.5m
R1957 n29758_29750 n29750_31206 8.5m
R1958 n29758_29750 n29049_29750 8.5m
R1959 n29758_29750 n29685_29758 8.5m
xmem1960 n29758_29750 n29758_30584 l1960 memristor
R1961 n29750_31206 n31206_31426 8.5m
R1962 n29750_31206 n29049_29750 8.5m
xmem1963 n29750_31206 n31206_32022 l1963 memristor
xmem1964 n19245_19479 n19018_19245 l1964 memristor
R1965 n19245_19479 n19479_21452 8.5m
xmem1966 n19245_19479 n18856_19245 l1966 memristor
xmem1967 n21060_23365 n23365_23920 l1967 memristor
xmem1968 n21060_23365 n21060_21074 l1968 memristor
xmem1969 n21060_23365 n21958_23365 l1969 memristor
R1970 n21060_23365 n20340_21060 8.5m
R1971 n23365_23920 n24593_23920 8.5m
xmem1972 n23365_23920 n23849_23920 l1972 memristor
R1973 n23365_23920 n21958_23365 8.5m
R1974 n38921_39325 n39422_39325 8.5m
R1975 n38921_39325 n39325_39497 8.5m
R1976 n38921_39325 n38293_38921 8.5m
xmem1977 n39422_39325 n39422_39768 l1977 memristor
xmem1978 n39422_39325 n39325_39497 l1978 memristor
xmem1979 n9161_9730 n9389_9730 l1979 memristor
R1980 n9161_9730 n8899_9161 8.5m
R1981 n9161_9730 n9161_9389 8.5m
xmem1982 n9161_9730 n9730_9811 l1982 memristor
xmem1983 n9389_9730 n9161_9389 l1983 memristor
xmem1984 n9389_9730 n9389_9564 l1984 memristor
R1985 n9389_9730 n9730_9811 8.5m
R1986 n52771_54189 n54189_54788 8.5m
R1987 n52771_54189 n54189_53749 8.5m
xmem1988 n52771_54189 n52295_52771 l1988 memristor
xmem1989 n52771_54189 n52832_52771 l1989 memristor
xmem1990 n54189_54788 n54189_53749 l1990 memristor
xmem1991 gnd n26087_26336 l1991 memristor
xmem1992 n50601_50794 n50210_50601 l1992 memristor
R1993 n31200_31417 n31417_31490 8.5m
xmem1994 n31200_31417 n30995_31200 l1994 memristor
R1995 n31200_31417 n31417_31490 8.5m
R1996 n31200_31417 n31119_31200 8.5m
R1997 n31417_31490 n31490_31930 8.5m
R1998 n9730_9811 n9564_9811 8.5m
R1999 n9730_9811 n9811_10451 8.5m
R2000 n9564_9811 n9811_10451 8.5m
R2001 n9564_9811 n9727_9564 8.5m
R2002 n9564_9811 n9389_9564 8.5m
xmem2003 n52439_52816 n52974_52816 l2003 memristor
xmem2004 n52439_52816 n52440_52439 l2004 memristor
xmem2005 n52439_52816 n52433_52439 l2005 memristor
R2006 n52974_52816 n52433_52974 8.5m
R2007 n4873_6102 n6102_6427 8.5m
R2008 n4873_6102 n6102_7299 8.5m
R2009 n4873_6102 n4873_6098 8.5m
xmem2010 n11637_12159 n12159_14520 l2010 memristor
xmem2011 n11637_12159 n11041_11637 l2011 memristor
xmem2012 n11637_12159 n12159_15559 l2012 memristor
R2013 n11637_12159 n11227_11637 8.5m
R2014 n12159_14520 n14520_15003 8.5m
R2015 n12159_14520 n12159_15559 8.5m
R2016 n12159_14520 n14520_15145 8.5m
R2017 n12778_13524 n12781_12778 8.5m
R2018 n36475_37291 n37291_37388 8.5m
xmem2019 n36475_37291 n36475_37145 l2019 memristor
xmem2020 n36475_37291 n37291_38360 l2020 memristor
xmem2021 n38138_40648 n40648_40647 l2021 memristor
xmem2022 n38138_40648 n37328_38138 l2022 memristor
R2023 n38138_40648 n37330_38138 8.5m
R2024 n38138_40648 n40648_40757 8.5m
xmem2025 n40648_40647 n40648_40757 l2025 memristor
R2026 n40648_40647 n40647_40752 8.5m
xmem2027 n40648_40647 n39701_40647 l2027 memristor
R2028 n22364_22285 n22285_22579 8.5m
xmem2029 n22364_22285 n21717_22364 l2029 memristor
xmem2030 n22364_22285 n22138_22285 l2030 memristor
xmem2031 n22285_22579 n22579_23072 l2031 memristor
R2032 n22285_22579 n22138_22285 8.5m
R2033 n8338_9097 n9097_9208 8.5m
xmem2034 n8338_9097 n7555_8338 l2034 memristor
R2035 n8338_9097 n9097_9766 8.5m
R2036 n8338_9097 n8338_8345 8.5m
xmem2037 n9097_9208 n9097_9766 l2037 memristor
R2038 n9097_9208 n8643_9208 8.5m
R2039 n9097_9208 n9208_9443 8.5m
xmem2040 n6102_7299 n7299_7528 l2040 memristor
R2041 n6102_7299 n6102_6427 8.5m
xmem2042 n6102_7299 n7299_7074 l2042 memristor
xmem2043 n7299_7528 n7299_7074 l2043 memristor
R2044 n7299_7528 n7528_7599 8.5m
xmem2045 n14359_15411 n15411_15417 l2045 memristor
R2046 n14359_15411 n14284_14359 8.5m
xmem2047 n14359_15411 n14359_15087 l2047 memristor
R2048 n14359_15411 n15411_16043 8.5m
R2049 n15411_15417 n15417_16194 8.5m
R2050 n15411_15417 n15411_16043 8.5m
R2051 n52963_53079 n52963_53269 8.5m
R2052 n52963_53079 n52935_53079 8.5m
xmem2053 n52963_53079 n53079_53269 l2053 memristor
xmem2054 n52963_53079 n52605_52963 l2054 memristor
R2055 n52963_53269 n53269_53564 8.5m
R2056 n52963_53269 n53079_53269 8.5m
R2057 n52963_53269 n52605_52963 8.5m
xmem2058 n32394_32798 n32798_32966 l2058 memristor
xmem2059 n32394_32798 n32394_33065 l2059 memristor
xmem2060 n32394_32798 n32037_32394 l2060 memristor
xmem2061 n32394_32798 n32798_33064 l2061 memristor
xmem2062 n32798_32966 n32966_33685 l2062 memristor
xmem2063 n32798_32966 n32966_33267 l2063 memristor
xmem2064 n32798_32966 n32798_33064 l2064 memristor
xmem2065 n4192_7432 n3790_4192 l2065 memristor
xmem2066 n4192_7432 n3790_4192 l2066 memristor
R2067 n35006_35436 n35436_35693 8.5m
xmem2068 n35006_35436 n35006_35272 l2068 memristor
xmem2069 n35006_35436 n31754_35006 l2069 memristor
R2070 n35006_35436 n35272_35436 8.5m
R2071 n35436_35693 n35693_36052 8.5m
xmem2072 n35436_35693 n35272_35436 l2072 memristor
R2073 n40203_40276 n39661_40203 8.5m
xmem2074 n40203_40276 n39562_40203 l2074 memristor
R2075 n6317_6320 n6317_7032 8.5m
R2076 n6317_6320 n5112_6317 8.5m
xmem2077 n6317_6320 n6320_7694 l2077 memristor
xmem2078 n6317_6320 n6069_6320 l2078 memristor
R2079 n6317_7032 n7032_7096 8.5m
R2080 n6317_7032 n7032_8166 8.5m
xmem2081 n6317_7032 n5112_6317 l2081 memristor
R2082 n42750_42886 n42886_43479 8.5m
R2083 n42750_42886 n42750_42806 8.5m
xmem2084 n42750_42886 n42058_42750 l2084 memristor
xmem2085 n42750_42886 n42874_42886 l2085 memristor
R2086 n42886_43479 n42874_42886 8.5m
R2087 n42886_43479 n43117_43479 8.5m
R2088 n42886_43479 n43479_44240 8.5m
R2089 n10569_10945 n10674_10945 8.5m
R2090 n10569_10945 n10569_10674 8.5m
xmem2091 n10569_10945 n10945_10948 l2091 memristor
R2092 n10569_10945 n9582_10569 8.5m
R2093 n10674_10945 n10945_10948 8.5m
xmem2094 n10674_10945 n10569_10674 l2094 memristor
R2095 n10674_10945 n10674_10948 8.5m
R2096 n21857_22059 n21777_21857 8.5m
R2097 n21857_22059 n22059_23422 8.5m
R2098 n21857_22059 n21691_21857 8.5m
R2099 n31570_32911 n32911_32913 8.5m
xmem2100 n31570_32911 n31570_31715 l2100 memristor
R2101 n31677_32087 n32087_32085 8.5m
R2102 n31677_32087 n31184_31677 8.5m
R2103 n32087_32085 n31677_32087 8.5m
R2104 n32087_32085 n32085_32200 8.5m
R2105 n32087_32085 n32085_32538 8.5m
R2106 n58338_58436 n58344_58338 8.5m
R2107 n58338_58436 n58391_58436 8.5m
R2108 n31268_31267 n31268_31342 8.5m
xmem2109 n31268_31267 n31267_31541 l2109 memristor
R2110 n31268_31267 n30987_31268 8.5m
R2111 n54222_54670 n54670_54812 8.5m
R2112 n54222_54670 n54402_54670 8.5m
R2113 n54222_54670 n54219_54222 8.5m
xmem2114 n54222_54670 n54222_54402 l2114 memristor
xmem2115 n54670_54812 n54402_54670 l2115 memristor
R2116 n54670_54812 n54600_54812 8.5m
xmem2117 n54670_54812 n54812_54934 l2117 memristor
xmem2118 n57551_57607 n57608_57607 l2118 memristor
R2119 n57551_57607 n57551_58075 8.5m
xmem2120 n57551_57607 n57551_57453 l2120 memristor
xmem2121 n9815_11433 n11021_11433 l2121 memristor
R2122 n9815_11433 n11433_11439 8.5m
R2123 n9815_11433 n9815_9571 8.5m
R2124 n9815_11433 n9395_9815 8.5m
xmem2125 n11021_11433 n9571_11021 l2125 memristor
R2126 n11021_11433 n11210_11021 8.5m
R2127 n11021_11433 n11433_11439 8.5m
R2128 n49138_49548 n49266_49548 8.5m
xmem2129 n49138_49548 n47632_49138 l2129 memristor
R2130 n49138_49548 n48955_49138 8.5m
xmem2131 n49138_49548 n49548_49616 l2131 memristor
R2132 n49266_49548 n49548_49616 8.5m
R2133 n48405_48698 n48174_48405 8.5m
xmem2134 n48405_48698 n48698_49505 l2134 memristor
xmem2135 n48405_48698 n48318_48405 l2135 memristor
R2136 n7032_8166 n8166_8167 8.5m
R2137 n7032_8166 n8166_8804 8.5m
R2138 n7032_8166 n7032_7096 8.5m
R2139 n8166_8167 n8166_8804 8.5m
R2140 n8166_8167 n7694_8167 8.5m
xmem2141 n8166_8167 n8167_8508 l2141 memristor
xmem2142 n53028_53341 n53026_53028 l2142 memristor
xmem2143 n53028_53341 n52610_53028 l2143 memristor
R2144 n55372_55429 n55429_55433 8.5m
xmem2145 n55372_55429 n55183_55372 l2145 memristor
xmem2146 n55372_55429 n55234_55372 l2146 memristor
R2147 n55372_55429 n55236_55429 8.5m
R2148 n55429_55433 n55433_55486 8.5m
xmem2149 n55429_55433 n55239_55433 l2149 memristor
xmem2150 n55429_55433 n55236_55429 l2150 memristor
R2151 n33516_34164 n34160_34164 8.5m
R2152 n33516_34164 n34164_34068 8.5m
R2153 n33516_34164 n33516_34068 8.5m
xmem2154 n34160_34164 n33352_34160 l2154 memristor
R2155 n34160_34164 n34164_34068 8.5m
xmem2156 n34160_34164 n34160_35260 l2156 memristor
R2157 n54555_54740 n54869_54740 8.5m
R2158 n54555_54740 n54740_55144 8.5m
R2159 n54555_54740 n54555_56506 8.5m
xmem2160 n54869_54740 n54474_54869 l2160 memristor
xmem2161 n54869_54740 n54869_55154 l2161 memristor
xmem2162 n54869_54740 n54740_55144 l2162 memristor
xmem2163 n29424_29806 n29342_29806 l2163 memristor
xmem2164 n29424_29806 n29806_29868 l2164 memristor
R2165 n46858_47359 n47359_47482 8.5m
xmem2166 n47359_47482 n47482_49177 l2166 memristor
R2167 n9421_9672 n9421_9591 8.5m
R2168 n9421_9672 n9414_9672 8.5m
xmem2169 n9421_9672 n8776_9421 l2169 memristor
xmem2170 n9421_9672 n9672_9835 l2170 memristor
xmem2171 n9421_9591 n8776_9421 l2171 memristor
R2172 n9421_9591 n9591_9835 8.5m
R2173 n9421_9591 n9591_9835 8.5m
R2174 n5265_5407 n5841_5407 8.5m
R2175 n5265_5407 n4926_5265 8.5m
xmem2176 n5265_5407 n5407_6013 l2176 memristor
R2177 n5265_5407 n4163_5265 8.5m
R2178 n5841_5407 n5407_6013 8.5m
R2179 n5841_5407 n5841_6195 8.5m
R2180 n5841_5407 n5263_5841 8.5m
xmem2181 n52440_52439 n52433_52439 l2181 memristor
R2182 n3918_5260 n5260_5263 8.5m
R2183 n3918_5260 n3758_3918 8.5m
R2184 n3918_5260 n3662_3918 8.5m
R2185 n3918_5260 n5260_6074 8.5m
R2186 n5260_5263 n5263_5841 8.5m
xmem2187 n5260_5263 n4924_5263 l2187 memristor
R2188 n5260_5263 n5260_6074 8.5m
xmem2189 n25919_26249 n26249_26871 l2189 memristor
R2190 n25919_26249 n25919_27085 8.5m
R2191 n25919_26249 n25916_25919 8.5m
R2192 n25919_26249 n26010_26249 8.5m
R2193 n26249_26871 n26871_26710 8.5m
R2194 n26249_26871 n26010_26249 8.5m
R2195 n26249_26871 n26871_27603 8.5m
R2196 n19182_19260 n19260_19870 8.5m
xmem2197 n19182_19260 n19255_19182 l2197 memristor
R2198 n19182_19260 n18870_19182 8.5m
xmem2199 n19182_19260 n19260_19650 l2199 memristor
R2200 n19260_19870 n19870_19868 8.5m
R2201 n19260_19870 n19260_19650 8.5m
R2202 n19260_19870 n19870_19951 8.5m
xmem2203 n34388_34559 n34559_35203 l2203 memristor
R2204 n34388_34559 n34475_34559 8.5m
R2205 n34388_34559 n34388_34379 8.5m
R2206 n34388_34559 n33626_34388 8.5m
R2207 n34559_35203 n34475_34559 8.5m
R2208 n25579_25916 n25916_25919 8.5m
xmem2209 n25579_25916 n24414_25579 l2209 memristor
R2210 n25579_25916 n25579_25745 8.5m
R2211 n25579_25916 n25916_26704 8.5m
xmem2212 n25916_25919 n25916_26704 l2212 memristor
xmem2213 n25916_25919 n25919_27085 l2213 memristor
R2214 n26468_26258 n26468_26710 8.5m
R2215 n26468_26258 n26010_26468 8.5m
R2216 n26468_26258 n26016_26258 8.5m
R2217 n26468_26258 n26258_26603 8.5m
R2218 n26468_26710 n26871_26710 8.5m
xmem2219 n26468_26710 n26010_26468 l2219 memristor
xmem2220 n26468_26710 n26710_27094 l2220 memristor
R2221 n30762_31093 n31093_31815 8.5m
R2222 n30762_31093 n30627_30762 8.5m
xmem2223 n30762_31093 n30366_30762 l2223 memristor
R2224 n30762_31093 n31093_31258 8.5m
xmem2225 n31093_31815 n31733_31815 l2225 memristor
R2226 n31093_31815 n31815_33115 8.5m
R2227 n31093_31815 n31093_31258 8.5m
xmem2228 n14359_15087 n14284_14359 l2228 memristor
R2229 n23895_23631 n23895_23966 8.5m
xmem2230 n23895_23631 n23046_23895 l2230 memristor
xmem2231 n23895_23631 n23135_23631 l2231 memristor
xmem2232 n23895_23966 n23046_23895 l2232 memristor
xmem2233 n37781_38172 n38172_38484 l2233 memristor
xmem2234 n37781_38172 n36382_37781 l2234 memristor
xmem2235 n37781_38172 n37781_38341 l2235 memristor
xmem2236 n37781_38172 n38172_38485 l2236 memristor
R2237 n38172_38484 n38172_38485 8.5m
xmem2238 n38172_38484 n38485_38484 l2238 memristor
xmem2239 n38172_38484 n38341_38484 l2239 memristor
xmem2240 n44072_44528 n44072_44471 l2240 memristor
R2241 n44072_44528 n43333_44072 8.5m
xmem2242 n44072_44528 n44528_44531 l2242 memristor
R2243 n5685_6351 n4949_5685 8.5m
xmem2244 n5685_6351 n6351_6978 l2244 memristor
xmem2245 n5685_6351 n5685_5686 l2245 memristor
R2246 n53269_53564 n53333_53564 8.5m
xmem2247 n53269_53564 n53079_53269 l2247 memristor
xmem2248 n53269_53564 n53564_54037 l2248 memristor
xmem2249 n22862_22965 n22862_23456 l2249 memristor
R2250 n22862_22965 n22875_22965 8.5m
xmem2251 n22862_22965 n22768_22862 l2251 memristor
R2252 n22862_22965 n22965_23458 8.5m
xmem2253 n22862_23456 n22768_22862 l2253 memristor
xmem2254 n38500_39128 n38500_39560 l2254 memristor
R2255 n38500_39128 n38121_38500 8.5m
xmem2256 n38500_39128 n39128_39316 l2256 memristor
R2257 n38500_39560 n39560_39562 8.5m
xmem2258 n38500_39560 n38121_38500 l2258 memristor
R2259 n38500_39560 n39560_39825 8.5m
xmem2260 n11885_11905 n11905_13159 l2260 memristor
R2261 n11885_11905 n11885_12379 8.5m
R2262 n11885_11905 n10376_11905 8.5m
R2263 n11885_11905 n11788_11885 8.5m
R2264 n11905_13159 n10376_11905 8.5m
R2265 n11905_13159 n13159_13154 8.5m
R2266 n11905_13159 n13159_13450 8.5m
R2267 n46309_46574 n46574_46728 8.5m
R2268 n46309_46574 n46309_46728 8.5m
R2269 n46309_46574 n46574_47259 8.5m
R2270 n39104_39629 n39629_41009 8.5m
xmem2271 n39104_39629 n39101_39629 l2271 memristor
xmem2272 n39629_41009 n39101_39629 l2272 memristor
xmem2273 n39629_41009 n41009_42296 l2273 memristor
R2274 n39629_41009 n39464_41009 8.5m
R2275 n33879_34704 n34704_35577 8.5m
xmem2276 n34704_35577 n33879_34704 l2276 memristor
xmem2277 n34704_35577 n35577_36682 l2277 memristor
R2278 n34704_35577 n35577_35324 8.5m
xmem2279 n19881_20577 n20577_20764 l2279 memristor
R2280 n19881_20577 n19339_19881 8.5m
xmem2281 n19881_20577 n20470_20577 l2281 memristor
xmem2282 n20577_20764 n20764_20981 l2282 memristor
xmem2283 n20577_20764 n20470_20577 l2283 memristor
R2284 n20577_20764 n21083_20764 8.5m
R2285 n52790_53076 n53076_53196 8.5m
R2286 n52790_53076 n52790_52935 8.5m
xmem2287 n52790_53076 n53076_53196 l2287 memristor
xmem2288 n52790_53076 n52790_52935 l2288 memristor
xmem2289 n52924_54638 n54638_54565 l2289 memristor
xmem2290 n52924_54638 n54638_54754 l2290 memristor
R2291 n52924_54638 n52924_53544 8.5m
R2292 n54638_54565 n54630_54565 8.5m
R2293 n54638_54565 n54565_54796 8.5m
xmem2294 n54638_54565 n54638_54754 l2294 memristor
R2295 n17744_18973 n18596_18973 8.5m
R2296 n17744_18973 n17600_17744 8.5m
R2297 n17744_18973 n17728_17744 8.5m
R2298 n17744_18973 n18973_19600 8.5m
xmem2299 n18596_18973 n18596_18598 l2299 memristor
xmem2300 n18596_18973 n17616_18596 l2300 memristor
R2301 n18596_18973 n18973_19600 8.5m
R2302 n26027_26380 n26380_27192 8.5m
xmem2303 n26027_26380 n26380_26999 l2303 memristor
R2304 n26027_26380 n25938_26027 8.5m
R2305 n26027_26380 n25938_26027 8.5m
R2306 n26380_27192 n26999_27192 8.5m
R2307 n26380_27192 n26380_26999 8.5m
R2308 n26380_27192 n27192_28455 8.5m
R2309 n17859_18861 n18861_19093 8.5m
xmem2310 n17859_18861 n16499_17859 l2310 memristor
R2311 n17859_18861 n16574_17859 8.5m
R2312 n17859_18861 n18861_18856 8.5m
R2313 n18861_19093 n19093_19785 8.5m
xmem2314 n18861_19093 n18861_18856 l2314 memristor
R2315 n18861_19093 n19093_19713 8.5m
R2316 n13670_13864 n13670_13962 8.5m
xmem2317 n13670_13864 n13864_14284 l2317 memristor
xmem2318 n13670_13864 n13039_13670 l2318 memristor
R2319 n13670_13864 n13299_13864 8.5m
xmem2320 n13670_13962 n13962_14284 l2320 memristor
R2321 n13670_13962 n13490_13962 8.5m
R2322 n13670_13962 n13039_13670 8.5m
xmem2323 n20990_22235 n20109_20990 l2323 memristor
R2324 n20990_22235 n20899_20990 8.5m
xmem2325 n20990_22235 n22235_22407 l2325 memristor
R2326 n7267_7884 n7884_7887 8.5m
xmem2327 n7267_7884 n7884_8609 l2327 memristor
xmem2328 n7267_7884 n6987_7267 l2328 memristor
R2329 n7267_7884 n6987_7267 8.5m
xmem2330 n7884_7887 n8057_7887 l2330 memristor
xmem2331 n7884_7887 n7884_8609 l2331 memristor
xmem2332 n7884_7887 n7344_7887 l2332 memristor
xmem2333 n20504_20398 n20403_20398 l2333 memristor
R2334 n20504_20398 n20398_20787 8.5m
xmem2335 n20504_20398 n20504_21022 l2335 memristor
R2336 n20504_20398 n19547_20504 8.5m
R2337 n20403_20398 n20398_20787 8.5m
xmem2338 n20403_20398 n20403_20787 l2338 memristor
R2339 n20403_20398 n20305_20403 8.5m
xmem2340 n24384_26188 n26188_27061 l2340 memristor
R2341 n24384_26188 n22630_24384 8.5m
xmem2342 n24384_26188 n24384_25816 l2342 memristor
R2343 n24384_26188 n26188_27564 8.5m
R2344 n26188_27061 n27061_27313 8.5m
xmem2345 n26188_27061 n26188_27564 l2345 memristor
xmem2346 n26188_27061 n27061_27059 l2346 memristor
xmem2347 n20457_20659 n20659_21558 l2347 memristor
xmem2348 n20457_20659 n20457_20345 l2348 memristor
R2349 n20457_20659 n20659_21074 8.5m
xmem2350 n20457_20659 n19401_20457 l2350 memristor
R2351 n20659_21558 n20659_21074 8.5m
R2352 n20659_21558 n21558_21888 8.5m
xmem2353 n3758_3918 n3662_3918 l2353 memristor
R2354 n3758_3918 n3657_3758 8.5m
xmem2355 n26066_26671 n26671_27311 l2355 memristor
xmem2356 n26066_26671 n25816_26066 l2356 memristor
xmem2357 n26066_26671 n26665_26066 l2357 memristor
R2358 n29825_30080 n30080_31119 8.5m
R2359 n29825_30080 n29822_29825 8.5m
xmem2360 n29825_30080 n29523_29825 l2360 memristor
xmem2361 n29825_30080 n29523_30080 l2361 memristor
xmem2362 n30080_31119 n29523_30080 l2362 memristor
R2363 n30080_31119 n31119_31130 8.5m
R2364 n30080_31119 n31119_31200 8.5m
xmem2365 n4095_4949 n4095_6408 l2365 memristor
R2366 n4095_4949 n4949_5685 8.5m
xmem2367 n4095_4949 n4095_4836 l2367 memristor
xmem2368 n4095_4949 n4836_4949 l2368 memristor
xmem2369 n4095_6408 n4095_4836 l2369 memristor
xmem2370 n4095_6408 n6408_6671 l2370 memristor
R2371 n25966_26420 n26420_26656 8.5m
R2372 n25966_26420 n25966_26661 8.5m
xmem2373 n25966_26420 n25623_25966 l2373 memristor
xmem2374 n25966_26420 n26059_26420 l2374 memristor
xmem2375 n26420_26656 n26059_26420 l2375 memristor
xmem2376 n26420_26656 n26661_26656 l2376 memristor
R2377 n26420_26656 n27687_26656 8.5m
R2378 n29868_30630 n30630_31094 8.5m
R2379 n29868_30630 n30369_30630 8.5m
xmem2380 n29868_30630 n29868_30262 l2380 memristor
R2381 n29868_30630 n29806_29868 8.5m
R2382 n30630_31094 n30369_30630 8.5m
xmem2383 n30630_31094 n31094_31258 l2383 memristor
R2384 n30630_31094 n30366_31094 8.5m
R2385 n47838_47995 n47506_47838 8.5m
xmem2386 n47838_47995 n47838_48955 l2386 memristor
R2387 n9097_9766 n9766_10323 8.5m
xmem2388 n9097_9766 n9766_10105 l2388 memristor
R2389 n54474_54869 n54869_55154 8.5m
R2390 n54474_54869 n54297_54474 8.5m
R2391 n54474_54869 n54474_54477 8.5m
R2392 n35080_37248 n37257_37248 8.5m
R2393 n35080_37248 n37248_38054 8.5m
R2394 n35080_37248 n34855_35080 8.5m
R2395 n37257_37248 n36297_37257 8.5m
xmem2396 n37257_37248 n37248_38054 l2396 memristor
xmem2397 n37257_37248 n37257_37343 l2397 memristor
xmem2398 n55175_55174 n55174_55610 l2398 memristor
R2399 n55175_55174 n55055_55174 8.5m
R2400 n55174_55610 n55610_55677 8.5m
R2401 n55174_55610 n55055_55174 8.5m
R2402 n55174_55610 n55228_55610 8.5m
R2403 n2893_2990 n3473_2990 8.5m
R2404 n2893_2990 n2990_3476 8.5m
xmem2405 n2893_2990 n2598_2893 l2405 memristor
xmem2406 n3473_2990 n3473_4120 l2406 memristor
xmem2407 n3473_2990 n3473_3476 l2407 memristor
R2408 n3473_2990 n2990_3476 8.5m
R2409 n10331_10613 n10331_10620 8.5m
xmem2410 n10331_10613 n10026_10331 l2410 memristor
xmem2411 n10331_10613 n10609_10613 l2411 memristor
R2412 n10331_10613 n10613_11066 8.5m
R2413 n10331_10620 n10026_10331 8.5m
xmem2414 n10331_10620 n10620_11066 l2414 memristor
xmem2415 n10331_10620 n10521_10620 l2415 memristor
R2416 n27911_27929 n27911_28242 8.5m
xmem2417 n27911_27929 n27929_29030 l2417 memristor
xmem2418 n27911_27929 n27930_27929 l2418 memristor
R2419 n27911_27929 n27723_27911 8.5m
R2420 n27911_28242 n27998_28242 8.5m
xmem2421 n27911_28242 n28242_29093 l2421 memristor
R2422 n27911_28242 n27723_27911 8.5m
xmem2423 vin n18081_18559 l2423 memristor
R2424 vin n18559_20529 8.5m
R2425 n28589_28962 n28962_29512 8.5m
xmem2426 n28589_28962 n27930_28962 l2426 memristor
R2427 n28589_28962 n27349_28589 8.5m
R2428 n28589_28962 n28589_28591 8.5m
xmem2429 n28962_29512 n27930_28962 l2429 memristor
xmem2430 n28962_29512 n29515_29512 l2430 memristor
xmem2431 n28962_29512 n29512_29607 l2431 memristor
xmem2432 n22016_22581 n22581_22780 l2432 memristor
R2433 n22016_22581 n21945_22016 8.5m
xmem2434 n22016_22581 n22581_22481 l2434 memristor
R2435 n22016_22581 n22016_22211 8.5m
xmem2436 n22581_22780 n22780_23358 l2436 memristor
R2437 n22581_22780 n22581_22481 8.5m
R2438 n22581_22780 n22780_23075 8.5m
R2439 n23378_24077 n24077_24433 8.5m
xmem2440 n23378_24077 n24077_24438 l2440 memristor
R2441 n23378_24077 n23377_23378 8.5m
xmem2442 n24077_24433 n24433_24911 l2442 memristor
R2443 n24077_24433 n24077_24438 8.5m
R2444 n24077_24433 n24438_24433 8.5m
xmem2445 n30987_30989 n30989_31344 l2445 memristor
xmem2446 n30987_30989 n30987_31268 l2446 memristor
xmem2447 n30987_30989 n30641_30987 l2447 memristor
xmem2448 n30987_30989 n30701_30989 l2448 memristor
R2449 n30989_31344 n31344_31342 8.5m
R2450 n30989_31344 n31344_31481 8.5m
R2451 n30989_31344 n30701_30989 8.5m
xmem2452 n25039_26800 n26800_27792 l2452 memristor
R2453 n25039_26800 n24970_25039 8.5m
xmem2454 n25039_26800 n26985_26800 l2454 memristor
R2455 n26800_27792 n26985_26800 8.5m
R2456 n26800_27792 n27792_27930 8.5m
xmem2457 n8773_9337 n9337_9414 l2457 memristor
R2458 n8773_9337 n8773_8776 8.5m
xmem2459 n8773_9337 n8841_8773 l2459 memristor
xmem2460 n9337_9414 n9414_9672 l2460 memristor
xmem2461 n9337_9414 n9414_10865 l2461 memristor
xmem2462 n37328_37399 n37399_38859 l2462 memristor
xmem2463 n37328_37399 n37396_37399 l2463 memristor
R2464 n37328_37399 n37237_37328 8.5m
xmem2465 n37328_37399 n37328_38138 l2465 memristor
xmem2466 n37399_38859 n38859_39068 l2466 memristor
R2467 n37399_38859 n37396_38859 8.5m
R2468 n37399_38859 n37396_37399 8.5m
xmem2469 n14119_14122 n14122_14693 l2469 memristor
xmem2470 n14119_14122 n12732_14122 l2470 memristor
R2471 n14119_14122 n14119_14194 8.5m
xmem2472 n14119_14122 n12242_14119 l2472 memristor
xmem2473 n14122_14693 n14697_14693 l2473 memristor
R2474 n14122_14693 n12732_14122 8.5m
R2475 n21298_21676 n21676_22630 8.5m
R2476 n21298_21676 n21112_21676 8.5m
R2477 n21676_22630 n21112_21676 8.5m
xmem2478 n21676_22630 n21509_22630 l2478 memristor
R2479 n21676_22630 n22630_24384 8.5m
R2480 n26234_26697 n26697_27081 8.5m
xmem2481 n26234_26697 n25094_26234 l2481 memristor
R2482 n26234_26697 n26697_26863 8.5m
R2483 n21074_21257 n21060_21074 8.5m
xmem2484 n21074_21257 n20659_21074 l2484 memristor
xmem2485 n1346_1544 n1544_2913 l2485 memristor
R2486 n1346_1544 n1035_1346 8.5m
R2487 n1346_1544 n1350_1346 8.5m
R2488 n1544_2913 n2913_3508 8.5m
xmem2489 n17531_17472 n17472_18175 l2489 memristor
xmem2490 n17531_17472 n17273_17472 l2490 memristor
R2491 n17531_17472 n17272_17531 8.5m
R2492 n17531_17472 n17531_18759 8.5m
R2493 n17472_18175 n18175_19035 8.5m
R2494 n17472_18175 n17273_17472 8.5m
R2495 n17472_18175 n18175_18761 8.5m
xmem2496 n40533_41147 n38935_40533 l2496 memristor
R2497 n40533_41147 n41147_41521 8.5m
R2498 n40533_41147 n40533_40771 8.5m
R2499 n56638_56881 n56828_56881 8.5m
R2500 n56638_56881 n56418_56638 8.5m
R2501 n56638_56881 n56881_57094 8.5m
xmem2502 n56638_56881 n56638_56828 l2502 memristor
R2503 n56828_56881 n56638_56828 8.5m
R2504 n56828_56881 n56881_57094 8.5m
xmem2505 n57551_58075 n58075_58363 l2505 memristor
R2506 n57551_58075 n57551_57453 8.5m
R2507 n13712_12917 n12444_12917 8.5m
R2508 n13712_12917 n13712_13992 8.5m
xmem2509 n13712_12917 n12367_13712 l2509 memristor
R2510 n12444_12917 n12367_12444 8.5m
xmem2511 n13631_14597 n14597_14901 l2511 memristor
R2512 n13631_14597 n13638_13631 8.5m
R2513 n13631_14597 n13905_14597 8.5m
xmem2514 n14597_14901 n14901_15787 l2514 memristor
xmem2515 n14597_14901 n13905_14597 l2515 memristor
xmem2516 n24637_25800 n25800_25887 l2516 memristor
xmem2517 n24637_25800 n24648_24637 l2517 memristor
R2518 n24637_25800 n24470_24637 8.5m
xmem2519 n24637_25800 n25800_25809 l2519 memristor
xmem2520 n25800_25887 n25800_25809 l2520 memristor
R2521 n25800_25887 n25794_25887 8.5m
xmem2522 n25800_25887 n25887_27143 l2522 memristor
xmem2523 n33478_33274 n33478_34475 l2523 memristor
R2524 n33478_33274 n32888_33274 8.5m
xmem2525 n33478_33274 n32721_33274 l2525 memristor
R2526 n33478_34475 n34475_34559 8.5m
R2527 n27515_27723 n27723_27911 8.5m
R2528 n27515_27723 n27269_27723 8.5m
R2529 n27515_27723 n27264_27515 8.5m
R2530 n27515_27723 n27269_27515 8.5m
xmem2531 n27723_27911 n27269_27723 l2531 memristor
R2532 n35283_35446 n35283_35529 8.5m
xmem2533 n35283_35446 n35283_36068 l2533 memristor
R2534 n35283_35446 n35446_36311 8.5m
R2535 n35283_35446 n35446_36311 8.5m
R2536 n35283_35529 n35529_36068 8.5m
R2537 n35283_35529 n35283_36068 8.5m
R2538 n35283_35529 n35529_35537 8.5m
R2539 n24903_24911 n24911_25604 8.5m
R2540 n24903_24911 n24903_25771 8.5m
xmem2541 n24903_24911 n23857_24903 l2541 memristor
R2542 n24903_24911 n24433_24911 8.5m
xmem2543 n24911_25604 n25604_25689 l2543 memristor
R2544 n24911_25604 n25604_25949 8.5m
xmem2545 n24911_25604 n24433_24911 l2545 memristor
R2546 n5263_5841 n5841_6195 8.5m
R2547 n5263_5841 n4924_5263 8.5m
R2548 n5841_6195 n6195_6259 8.5m
R2549 n5841_6195 n6195_6740 8.5m
R2550 n33557_33626 n33626_34388 8.5m
R2551 n33557_33626 n34119_33626 8.5m
R2552 n33557_33626 n32037_33557 8.5m
xmem2553 n33557_33626 n33557_33553 l2553 memristor
R2554 n33626_34388 n34119_33626 8.5m
R2555 n33626_34388 n34388_34379 8.5m
xmem2556 n39841_40208 n40208_40575 l2556 memristor
xmem2557 n39841_40208 n39841_39836 l2557 memristor
xmem2558 n39841_40208 n39497_39841 l2558 memristor
R2559 n15749_17834 n17834_18809 8.5m
xmem2560 n15749_17834 n17834_19066 l2560 memristor
R2561 n15749_17834 n15749_15342 8.5m
xmem2562 n15749_17834 n15093_15749 l2562 memristor
R2563 n17834_18809 n17834_19066 8.5m
xmem2564 n17834_18809 n18809_19547 l2564 memristor
xmem2565 n17834_18809 n18809_19449 l2565 memristor
xmem2566 n39173_39464 n39464_41009 l2566 memristor
R2567 n39173_39464 n39263_39173 8.5m
xmem2568 n39173_39464 n34304_39173 l2568 memristor
xmem2569 n39464_41009 n41009_42296 l2569 memristor
xmem2570 n14488_14487 n14488_15111 l2570 memristor
R2571 n14488_14487 n14316_14488 8.5m
xmem2572 n14488_14487 n14387_14487 l2572 memristor
R2573 n14488_14487 n14487_15683 8.5m
xmem2574 n14488_15111 n14489_15111 l2574 memristor
xmem2575 n14488_15111 n15111_15444 l2575 memristor
xmem2576 n14488_15111 n14316_14488 l2576 memristor
R2577 n14520_15003 n15003_15133 8.5m
xmem2578 n14520_15003 n14999_15003 l2578 memristor
xmem2579 n14520_15003 n14520_15145 l2579 memristor
xmem2580 n15003_15133 n14999_15003 l2580 memristor
xmem2581 n15003_15133 n15133_15134 l2581 memristor
R2582 n15003_15133 n15133_15709 8.5m
R2583 n12242_13757 n13757_14194 8.5m
R2584 n12242_13757 n12242_14119 8.5m
R2585 n12242_13757 n12079_12242 8.5m
R2586 n12242_13757 n13757_13756 8.5m
xmem2587 n13757_14194 n14119_14194 l2587 memristor
R2588 n13757_14194 n13757_13756 8.5m
R2589 n13757_14194 n14194_14437 8.5m
xmem2590 n52935_53079 n52790_52935 l2590 memristor
R2591 n52935_53079 n52935_53196 8.5m
R2592 n52935_53079 n53079_53269 8.5m
xmem2593 n9858_10189 n10187_10189 l2593 memristor
R2594 n9858_10189 n10189_10606 8.5m
R2595 n9858_10189 n8940_9858 8.5m
R2596 n9858_10189 n9858_9930 8.5m
xmem2597 n10187_10189 n10187_10327 l2597 memristor
R2598 n10187_10189 n9615_10187 8.5m
xmem2599 n10187_10189 n10189_10606 l2599 memristor
R2600 n50423_50510 n50423_50558 8.5m
xmem2601 n50423_50510 n50510_50558 l2601 memristor
xmem2602 n50423_50510 n49904_50423 l2602 memristor
R2603 n50423_50510 n50510_50558 8.5m
R2604 n50423_50558 n50510_50558 8.5m
xmem2605 n50423_50558 n50510_50558 l2605 memristor
R2606 n50423_50558 n49904_50423 8.5m
xmem2607 n43656_44202 n43573_43656 l2607 memristor
R2608 n44703_44871 n44655_44871 8.5m
xmem2609 n44703_44871 n44703_44655 l2609 memristor
R2610 n44703_44871 n44871_45840 8.5m
R2611 n44703_44871 n44052_44703 8.5m
xmem2612 n44655_44871 n44060_44655 l2612 memristor
xmem2613 n44655_44871 n44871_45840 l2613 memristor
xmem2614 n44655_44871 n44703_44655 l2614 memristor
R2615 n13389_13765 n13764_13765 8.5m
xmem2616 n13389_13765 n13293_13389 l2616 memristor
xmem2617 n13389_13765 n13765_14276 l2617 memristor
xmem2618 n13389_13765 n13389_13951 l2618 memristor
R2619 n13764_13765 n13765_14276 8.5m
R2620 n13764_13765 n13387_13764 8.5m
xmem2621 n13764_13765 n13293_13764 l2621 memristor
xmem2622 n34232_34236 n34236_34448 l2622 memristor
xmem2623 n34232_34236 n33860_34236 l2623 memristor
xmem2624 n34232_34236 n34232_34230 l2624 memristor
xmem2625 n34232_34236 n33685_34232 l2625 memristor
xmem2626 n34236_34448 n33860_34236 l2626 memristor
R2627 n8953_9948 n9948_10196 8.5m
xmem2628 n8953_9948 n8033_8953 l2628 memristor
xmem2629 n8953_9948 n9948_10196 l2629 memristor
R2630 n9948_10196 n10338_10196 8.5m
R2631 n32798_33064 n33064_33860 8.5m
xmem2632 n32798_33064 n33065_33064 l2632 memristor
xmem2633 n33064_33860 n33065_33064 l2633 memristor
xmem2634 n33064_33860 n33685_33860 l2634 memristor
xmem2635 n33064_33860 n33860_34236 l2635 memristor
R2636 n51556_51750 n51750_52223 8.5m
R2637 n51556_51750 n51556_51563 8.5m
R2638 n51556_51750 n51243_51556 8.5m
xmem2639 n51556_51750 n51742_51750 l2639 memristor
R2640 n51750_52223 n51563_52223 8.5m
R2641 n51750_52223 n51742_51750 8.5m
xmem2642 n10338_11184 n11184_11404 l2642 memristor
R2643 n10338_11184 n4163_10338 8.5m
xmem2644 n10338_11184 n10338_10196 l2644 memristor
R2645 n10338_11184 n11184_11585 8.5m
R2646 n11184_11404 n11184_11585 8.5m
xmem2647 n11184_11404 n11404_11585 l2647 memristor
R2648 n24438_24433 n24433_24911 8.5m
R2649 n24438_24433 n24077_24438 8.5m
xmem2650 n24438_24433 n24438_24524 l2650 memristor
xmem2651 n12645_13260 n13260_13266 l2651 memristor
R2652 n12645_13260 n12645_12870 8.5m
xmem2653 n13260_13266 n13271_13266 l2653 memristor
xmem2654 n13260_13266 n12870_13266 l2654 memristor
xmem2655 n38935_40533 n40533_40771 l2655 memristor
xmem2656 n10881_11054 n9443_10881 l2656 memristor
xmem2657 n54402_54670 n54402_54600 l2657 memristor
xmem2658 n54402_54670 n54222_54402 l2658 memristor
R2659 n16158_16153 n16152_16153 8.5m
xmem2660 n16158_16153 n16153_16574 l2660 memristor
R2661 n16152_16153 n16014_16152 8.5m
xmem2662 n16152_16153 n16153_16574 l2662 memristor
R2663 n16152_16153 n16152_16231 8.5m
R2664 n6077_6837 n6837_8033 8.5m
xmem2665 n6077_6837 n6013_6077 l2665 memristor
xmem2666 n6077_6837 n6077_6264 l2666 memristor
R2667 n6077_6837 n6836_6837 8.5m
R2668 n6837_8033 n6836_6837 8.5m
R2669 n6837_8033 n7567_8033 8.5m
xmem2670 n6837_8033 n8033_8953 l2670 memristor
R2671 n12927_13530 n13530_14079 8.5m
xmem2672 n12927_13530 n13530_14006 l2672 memristor
R2673 n12927_13530 n12927_13720 8.5m
R2674 n12927_13530 n12781_12927 8.5m
R2675 n13530_14079 n14079_14244 8.5m
xmem2676 n13530_14079 n13530_14006 l2676 memristor
R2677 n13530_14079 n14006_14079 8.5m
R2678 n17033_17026 n17026_17273 8.5m
R2679 n17033_17026 n17346_17033 8.5m
R2680 n17033_17026 n16445_17026 8.5m
R2681 n17033_17026 n16262_17033 8.5m
R2682 n17026_17273 n16445_17026 8.5m
R2683 n17026_17273 n17273_17472 8.5m
R2684 n17026_17273 n16677_17273 8.5m
xmem2685 n50290_50339 n50339_50678 l2685 memristor
xmem2686 n50290_50339 n50339_52067 l2686 memristor
R2687 n19066_19528 n19528_20925 8.5m
R2688 n19066_19528 n19528_19911 8.5m
xmem2689 n19066_19528 n17834_19066 l2689 memristor
R2690 n19528_20925 n19528_19911 8.5m
xmem2691 n19528_20925 n20925_21403 l2691 memristor
xmem2692 n12781_12778 n12781_12927 l2692 memristor
R2693 n12781_12778 n11868_12781 8.5m
R2694 n12781_12927 n12927_13720 8.5m
xmem2695 n12781_12927 n11868_12781 l2695 memristor
xmem2696 n16901_17272 n17272_17531 l2696 memristor
xmem2697 n16901_17272 n16596_16901 l2697 memristor
xmem2698 n16901_17272 n16518_16901 l2698 memristor
R2699 n16901_17272 n16677_17272 8.5m
xmem2700 n17272_17531 n17531_18759 l2700 memristor
xmem2701 n17272_17531 n16677_17272 l2701 memristor
xmem2702 n994_1400 n1400_1441 l2702 memristor
R2703 n994_1400 n1400_1441 8.5m
R2704 n994_1400 n496_994 8.5m
R2705 n994_1400 n994_993 8.5m
R2706 n38268_38618 n38102_38268 8.5m
xmem2707 n11658_12184 n12184_12262 l2707 memristor
xmem2708 n11658_12184 n10727_11658 l2708 memristor
R2709 n11658_12184 n12184_12262 8.5m
R2710 n11658_12184 n11658_12262 8.5m
R2711 n12184_12262 n11658_12262 8.5m
R2712 n12485_12732 n12732_14122 8.5m
xmem2713 n12485_12732 n12485_13108 l2713 memristor
R2714 n32200_32357 n32200_32446 8.5m
xmem2715 n32200_32357 n32357_32773 l2715 memristor
R2716 n32200_32357 n32085_32200 8.5m
R2717 n32200_32446 n32085_32200 8.5m
R2718 n32200_32446 n32446_32773 8.5m
R2719 n32200_32446 n32538_32446 8.5m
R2720 n18559_20529 n20529_22548 8.5m
xmem2721 n18559_20529 n18081_18559 l2721 memristor
xmem2722 n31169_31663 n31663_32073 l2722 memristor
R2723 n31169_31663 n31663_32344 8.5m
R2724 n31663_32073 n31733_32073 8.5m
R2725 n31663_32073 n31663_32344 8.5m
xmem2726 n30627_30762 n30627_30624 l2726 memristor
R2727 n30627_30762 n30057_30627 8.5m
R2728 n30627_30762 n30366_30762 8.5m
R2729 n30627_30624 n30624_31248 8.5m
xmem2730 n30627_30624 n30057_30627 l2730 memristor
R2731 n30627_30624 n30559_30624 8.5m
xmem2732 n23700_24084 n24084_25881 l2732 memristor
R2733 n23700_24084 n23400_23700 8.5m
R2734 n23700_24084 n24090_24084 8.5m
xmem2735 n23700_24084 n23297_23700 l2735 memristor
R2736 n24084_25881 n25881_26823 8.5m
R2737 n24084_25881 n24090_24084 8.5m
xmem2738 n31980_32837 n31982_32837 l2738 memristor
R2739 n31980_32837 n31980_31982 8.5m
R2740 n31980_32837 n32837_33332 8.5m
R2741 n31982_32837 n31980_31982 8.5m
R2742 n31982_32837 n31988_31982 8.5m
R2743 n31982_32837 n32837_33332 8.5m
R2744 n27085_27603 n27603_27998 8.5m
R2745 n27085_27603 n26871_27603 8.5m
xmem2746 n27085_27603 n25919_27085 l2746 memristor
xmem2747 n27085_27603 n27085_27844 l2747 memristor
R2748 n27603_27998 n27998_28242 8.5m
R2749 n27603_27998 n26871_27603 8.5m
R2750 n39664_39910 n39910_40449 8.5m
R2751 n45226_45992 n45992_45994 8.5m
R2752 n45226_45992 n45992_46395 8.5m
xmem2753 n45226_45992 n45311_45226 l2753 memristor
R2754 n45226_45992 n42037_45226 8.5m
R2755 n45992_45994 n45994_46395 8.5m
R2756 n45992_45994 n45992_46395 8.5m
R2757 n45992_45994 n45379_45994 8.5m
R2758 n27814_28766 n28766_29210 8.5m
R2759 n27814_28766 n27879_27814 8.5m
R2760 n27814_28766 n28766_29210 8.5m
R2761 n27814_28766 n28766_29284 8.5m
R2762 n28766_29210 n28766_29284 8.5m
xmem2763 n28766_29210 n29284_29210 l2763 memristor
R2764 n32888_33274 n32721_33274 8.5m
R2765 n32888_33274 n32565_32888 8.5m
xmem2766 n32888_33274 n32891_32888 l2766 memristor
R2767 n37248_38054 n38054_38743 8.5m
xmem2768 n17273_17472 n16677_17273 l2768 memristor
xmem2769 n54572_55241 n54570_54572 l2769 memristor
xmem2770 n25919_27085 n27085_27844 l2770 memristor
R2771 n41253_41682 n41682_41623 8.5m
xmem2772 n41253_41682 n41258_41253 l2772 memristor
xmem2773 n41253_41682 n41252_41253 l2773 memristor
R2774 n41253_41682 n40826_41682 8.5m
R2775 n41682_41623 n41623_41751 8.5m
xmem2776 n41682_41623 n41263_41623 l2776 memristor
R2777 n41682_41623 n40826_41682 8.5m
R2778 n30157_30995 n30076_30157 8.5m
R2779 n30157_30995 n30995_31200 8.5m
R2780 n11227_11040 n11040_11041 8.5m
R2781 n11227_11040 n10789_11227 8.5m
R2782 n11227_11040 n11227_11637 8.5m
R2783 n11227_11040 n10792_11040 8.5m
R2784 n11040_11041 n10792_11040 8.5m
R2785 n11040_11041 n11041_11637 8.5m
xmem2786 n11040_11041 n11041_11922 l2786 memristor
R2787 n8776_9421 n9426_8776 8.5m
R2788 n8776_9421 n8773_8776 8.5m
xmem2789 n56181_56258 n55853_56181 l2789 memristor
R2790 n56181_56258 n55696_56258 8.5m
R2791 n9628_10051 n10056_10051 8.5m
R2792 n9628_10051 n9628_10349 8.5m
R2793 n9628_10051 n8527_9628 8.5m
xmem2794 n9628_10051 n10051_10350 l2794 memristor
R2795 n10056_10051 n8537_10056 8.5m
R2796 n10056_10051 n10051_10350 8.5m
R2797 n10056_10051 n8537_10056 8.5m
R2798 n47482_49177 n49177_50001 8.5m
R2799 n47482_49177 n49177_49838 8.5m
xmem2800 n49177_50001 n50001_49838 l2800 memristor
xmem2801 n49177_50001 n49177_49838 l2801 memristor
R2802 n49177_50001 n50001_50435 8.5m
R2803 n24039_24863 n24863_24768 8.5m
R2804 n24039_24863 n24863_25562 8.5m
R2805 n24863_24768 n24768_25562 8.5m
R2806 n24863_24768 n23435_24768 8.5m
xmem2807 n24863_24768 n24863_25562 l2807 memristor
R2808 n35283_36068 n36068_36313 8.5m
xmem2809 n35283_36068 n35529_36068 l2809 memristor
R2810 n52073_52295 n52067_52073 8.5m
R2811 n52073_52295 n52295_52771 8.5m
xmem2812 n6102_6427 n6427_7074 l2812 memristor
R2813 n6102_6427 n6425_6427 8.5m
R2814 n20237_22451 n20158_20237 8.5m
xmem2815 n55563_54936 n54600_54936 l2815 memristor
R2816 n55563_54936 n53279_55563 8.5m
R2817 n55563_54936 n54936_54934 8.5m
xmem2818 n54600_54936 n54600_54812 l2818 memristor
R2819 n54600_54936 n54402_54600 8.5m
xmem2820 n54600_54936 n54936_54934 l2820 memristor
R2821 n12854_13011 n13011_13442 8.5m
R2822 n12854_13011 n12854_13152 8.5m
xmem2823 n12854_13011 n13011_13154 l2823 memristor
xmem2824 n13011_13442 n13011_13154 l2824 memristor
R2825 n13011_13442 n13442_13816 8.5m
R2826 n13011_13442 n13442_13446 8.5m
xmem2827 n25548_25816 n25548_26665 l2827 memristor
xmem2828 n25548_25816 n24384_25816 l2828 memristor
R2829 n25548_25816 n25816_26066 8.5m
R2830 n43535_43886 n43812_43886 8.5m
R2831 n43535_43886 n43984_43886 8.5m
R2832 n43535_43886 n43535_43812 8.5m
R2833 n43535_43886 n43270_43535 8.5m
R2834 n43812_43886 n43812_44604 8.5m
R2835 n43812_43886 n43984_43886 8.5m
xmem2836 n43812_43886 n43535_43812 l2836 memristor
xmem2837 n26871_27603 n26871_26710 l2837 memristor
R2838 n45995_45996 n45996_46619 8.5m
xmem2839 n45995_45996 n45840_45995 l2839 memristor
R2840 n40648_40757 n40757_41252 8.5m
xmem2841 n40648_40757 n40759_40757 l2841 memristor
xmem2842 n40757_41252 n40759_40757 l2842 memristor
xmem2843 n40757_41252 n40752_41252 l2843 memristor
xmem2844 n40757_41252 n41252_41253 l2844 memristor
xmem2845 n22750_23058 n23058_24200 l2845 memristor
R2846 n22750_23058 n22750_22757 8.5m
R2847 n22750_23058 n23058_23542 8.5m
R2848 n23058_24200 n23823_24200 8.5m
xmem2849 n23058_24200 n23058_23542 l2849 memristor
R2850 n57608_57607 n57608_57887 8.5m
R2851 n57608_57607 n57453_57608 8.5m
R2852 n22508_23277 n23277_23171 8.5m
xmem2853 n22508_23277 n22508_23377 l2853 memristor
R2854 n22508_23277 n21745_22508 8.5m
R2855 n22508_23277 n23277_23577 8.5m
xmem2856 n23277_23171 n22806_23171 l2856 memristor
R2857 n23277_23171 n23277_23577 8.5m
R2858 n3625_3974 n3304_3625 8.5m
R2859 n14426_14606 n14606_14992 8.5m
xmem2860 n14426_14606 n14426_14264 l2860 memristor
R2861 n14426_14606 n14604_14606 8.5m
R2862 n14606_14992 n14604_14606 8.5m
R2863 n14606_14992 n14992_15225 8.5m
R2864 n37396_38859 n38859_39068 8.5m
xmem2865 n37396_38859 n37396_37399 l2865 memristor
xmem2866 n38859_39068 n39068_39229 l2866 memristor
xmem2867 n14704_14705 n13567_14704 l2867 memristor
R2868 n14704_14705 n14704_15325 8.5m
xmem2869 n26823_26398 n25881_26823 l2869 memristor
R2870 n26823_26398 n26398_26632 8.5m
R2871 n26823_26398 n26398_26632 8.5m
xmem2872 n53423_53935 n53475_53935 l2872 memristor
xmem2873 n53423_53935 n53935_54052 l2873 memristor
xmem2874 n53423_53935 n53423_53475 l2874 memristor
xmem2875 n53475_53935 n53935_54052 l2875 memristor
xmem2876 n53475_53935 n53423_53475 l2876 memristor
xmem2877 n53475_53935 n52912_53475 l2877 memristor
R2878 n44679_44835 n44835_45271 8.5m
R2879 n44679_44835 n44835_45271 8.5m
R2880 n44679_44835 n42541_44679 8.5m
xmem2881 n16177_16262 n16262_17033 l2881 memristor
R2882 n16177_16262 n15804_16177 8.5m
R2883 n16177_16262 n16262_17346 8.5m
R2884 n16177_16262 n16445_16177 8.5m
xmem2885 n16262_17033 n17346_17033 l2885 memristor
R2886 n16262_17033 n16262_17346 8.5m
R2887 n22403_22325 n22325_23400 8.5m
R2888 n22403_22325 n22403_23105 8.5m
R2889 n22403_22325 n22325_22326 8.5m
R2890 n22403_22325 n22102_22403 8.5m
R2891 n22325_23400 n23400_23700 8.5m
xmem2892 n22325_23400 n22325_22326 l2892 memristor
xmem2893 n26258_26603 n26603_27094 l2893 memristor
R2894 n26258_26603 n26603_27264 8.5m
xmem2895 n26258_26603 n26016_26258 l2895 memristor
R2896 n26603_27094 n26710_27094 8.5m
xmem2897 n26603_27094 n26603_27264 l2897 memristor
xmem2898 n26603_27094 n27264_27094 l2898 memristor
R2899 n36302_36568 n36302_36428 8.5m
R2900 n36302_36568 n36568_36888 8.5m
R2901 n36302_36568 n36568_36562 8.5m
R2902 n36302_36428 n36428_36888 8.5m
xmem2903 n36302_36428 n36428_36957 l2903 memristor
xmem2904 n2913_3508 n3508_4924 l2904 memristor
R2905 n2913_3508 n3508_3505 8.5m
R2906 n45734_45805 n45663_45734 8.5m
R2907 n45734_45805 n45805_46787 8.5m
xmem2908 n45734_45805 n45663_45734 l2908 memristor
R2909 n633_1035 n1035_1346 8.5m
xmem2910 n633_1035 n588_633 l2910 memristor
R2911 n633_1035 n588_633 8.5m
xmem2912 n633_1035 n1035_1346 l2912 memristor
R2913 n17346_17473 n17478_17473 8.5m
R2914 n17346_17473 n16262_17346 8.5m
R2915 n17346_17473 n17346_17033 8.5m
xmem2916 n17478_17473 n17478_17728 l2916 memristor
R2917 n17478_17473 n17215_17478 8.5m
R2918 n9811_10451 n10451_11349 8.5m
xmem2919 n9811_10451 n9971_10451 l2919 memristor
R2920 n37291_37388 n37529_37388 8.5m
xmem2921 n37291_37388 n37145_37388 l2921 memristor
R2922 n37291_37388 n37291_38360 8.5m
R2923 n28455_28892 n28892_29515 8.5m
R2924 n28455_28892 n28591_28892 8.5m
xmem2925 n28455_28892 n27856_28455 l2925 memristor
R2926 n28455_28892 n27192_28455 8.5m
xmem2927 n28892_29515 n28591_28892 l2927 memristor
xmem2928 n28892_29515 n29515_29810 l2928 memristor
R2929 n28892_29515 n29515_29512 8.5m
R2930 n3397_3695 n3695_6156 8.5m
R2931 n3397_3695 n3695_4399 8.5m
R2932 n3397_3695 n3397_4399 8.5m
R2933 n3397_3695 n2933_3397 8.5m
R2934 n3695_6156 n6156_6219 8.5m
xmem2935 n3695_6156 n4867_6156 l2935 memristor
R2936 n3695_6156 n3695_4399 8.5m
xmem2937 n8537_10056 n8527_8537 l2937 memristor
xmem2938 n8537_10056 n8527_8537 l2938 memristor
xmem2939 n40068_39963 n39963_40327 l2939 memristor
xmem2940 n40068_39963 n38485_40068 l2940 memristor
R2941 n39963_40327 n40327_43142 8.5m
R2942 n39963_40327 n40068_39963 8.5m
R2943 n39963_40327 n40327_40874 8.5m
R2944 n39263_39173 n34304_39173 8.5m
R2945 n11019_10760 n11019_11115 8.5m
R2946 n6195_6259 n6195_6740 8.5m
xmem2947 n6195_6259 n6259_6451 l2947 memristor
xmem2948 n6195_6259 n6259_7567 l2948 memristor
xmem2949 n6195_6740 n6740_6828 l2949 memristor
R2950 n6195_6740 n6740_7945 8.5m
R2951 n30987_31268 n30641_30987 8.5m
xmem2952 n30987_31268 n31268_31342 l2952 memristor
R2953 n49838_50435 n50435_50665 8.5m
R2954 n49838_50435 n50001_49838 8.5m
xmem2955 n49838_50435 n49177_49838 l2955 memristor
xmem2956 n49838_50435 n50001_50435 l2956 memristor
R2957 n50435_50665 n50001_50435 8.5m
xmem2958 n50435_50665 n50715_50665 l2958 memristor
R2959 n50435_50665 n50665_50906 8.5m
xmem2960 n13076_13998 n13998_14232 l2960 memristor
R2961 n13076_13998 n12054_13076 8.5m
xmem2962 n13076_13998 n13076_13523 l2962 memristor
R2963 n13076_13998 n13998_13992 8.5m
xmem2964 n13998_14232 n14232_14484 l2964 memristor
R2965 n13998_14232 n14232_14484 8.5m
xmem2966 n13998_14232 n13998_13992 l2966 memristor
R2967 n18498_18766 n18766_18963 8.5m
xmem2968 n18498_18766 n18761_18766 l2968 memristor
R2969 n6098_6425 n6098_6604 8.5m
xmem2970 n6098_6425 n6425_6604 l2970 memristor
R2971 n6098_6425 n4873_6098 8.5m
R2972 n6098_6425 n6425_6427 8.5m
R2973 n6098_6604 n6604_7072 8.5m
xmem2974 n6098_6604 n6425_6604 l2974 memristor
R2975 n6098_6604 n4873_6098 8.5m
R2976 n19479_21452 n21452_21958 8.5m
xmem2977 n38338_36382 n36382_37781 l2977 memristor
xmem2978 n6338_6671 n6671_6769 l2978 memristor
R2979 n6338_6671 n6408_6671 8.5m
xmem2980 n6671_6769 n6769_7113 l2980 memristor
R2981 n6671_6769 n6408_6671 8.5m
xmem2982 n6671_6769 n6769_7113 l2982 memristor
xmem2983 n26871_26710 n26710_27094 l2983 memristor
xmem2984 n8166_8804 n8804_8803 l2984 memristor
R2985 n8166_8804 n8804_8940 8.5m
xmem2986 n54638_54754 n54641_54754 l2986 memristor
xmem2987 n54638_54754 n54754_55055 l2987 memristor
R2988 n54641_54754 n54754_55055 8.5m
R2989 n54641_54754 n54570_54641 8.5m
xmem2990 n54641_54754 n54570_54641 l2990 memristor
R2991 n8329_8230 n8329_8923 8.5m
R2992 n8329_8230 n7165_8329 8.5m
R2993 n8329_8230 n8238_8230 8.5m
R2994 n8329_8923 n8923_10792 8.5m
xmem2995 n8329_8923 n8923_10177 l2995 memristor
R2996 n8329_8923 n7165_8329 8.5m
xmem2997 n36568_36888 n36428_36888 l2997 memristor
R2998 n36568_36888 n36568_36562 8.5m
R2999 n36568_36888 n36888_37420 8.5m
xmem3000 n36428_36888 n36888_37420 l3000 memristor
R3001 n36428_36888 n36428_36957 8.5m
R3002 n34230_33936 n33755_34230 8.5m
R3003 n34230_33936 n34232_34230 8.5m
R3004 n22548_22748 n22548_23135 8.5m
R3005 n22548_22748 n20529_22548 8.5m
R3006 n22548_23135 n23135_23631 8.5m
R3007 n22548_23135 n23135_23046 8.5m
xmem3008 n22548_23135 n20529_22548 l3008 memristor
xmem3009 n15535_16302 n16305_16302 l3009 memristor
xmem3010 n15535_16302 n16302_16418 l3010 memristor
R3011 n16305_16302 n15607_16305 8.5m
R3012 n16305_16302 n16305_16418 8.5m
R3013 n16305_16302 n16302_16418 8.5m
xmem3014 n4924_4926 n4163_4926 l3014 memristor
R3015 n4924_4926 n4926_5265 8.5m
R3016 n4924_4926 n3508_4924 8.5m
R3017 n4924_4926 n4924_5263 8.5m
xmem3018 n4163_4926 n4163_5265 l3018 memristor
xmem3019 n4163_4926 n4163_10338 l3019 memristor
xmem3020 n4163_4926 n4926_5265 l3020 memristor
R3021 n44871_45840 n45840_45995 8.5m
R3022 n44871_45840 n45840_45379 8.5m
xmem3023 n45840_45995 n45840_45379 l3023 memristor
R3024 n26291_27008 n27008_27283 8.5m
R3025 n26291_27008 n25949_26291 8.5m
R3026 n26291_27008 n27008_27744 8.5m
xmem3027 n26291_27008 n26816_26291 l3027 memristor
R3028 n27008_27283 n27285_27283 8.5m
xmem3029 n27008_27283 n27283_27744 l3029 memristor
xmem3030 n27008_27283 n27008_27744 l3030 memristor
xmem3031 n53279_55563 n52533_53279 l3031 memristor
R3032 n53279_55563 n52349_53279 8.5m
R3033 n14214_14539 n13868_14214 8.5m
R3034 n14214_14539 n14539_14543 8.5m
R3035 n14214_14539 n13965_14214 8.5m
R3036 n25966_26661 n26661_27031 8.5m
R3037 n25966_26661 n26661_26656 8.5m
xmem3038 n25966_26661 n25623_25966 l3038 memristor
R3039 n26661_27031 n27031_27223 8.5m
xmem3040 n26661_27031 n26661_26656 l3040 memristor
xmem3041 n26661_27031 n27031_27630 l3041 memristor
R3042 n21191_24653 n21011_21191 8.5m
R3043 n21191_24653 n20778_21191 8.5m
R3044 n21191_24653 n24653_24312 8.5m
R3045 n38293_38921 n38360_38293 8.5m
R3046 n25800_25809 n25809_27687 8.5m
xmem3047 n25800_25809 n25265_25809 l3047 memristor
R3048 n52139_52251 n52251_52509 8.5m
xmem3049 n52139_52251 n52139_52508 l3049 memristor
R3050 n52251_52509 n52139_52251 8.5m
xmem3051 n48701_49505 n48698_49505 l3051 memristor
R3052 n48701_49505 n48708_48701 8.5m
xmem3053 n48701_49505 n49505_48993 l3053 memristor
R3054 n48701_49505 n48318_48701 8.5m
R3055 n48698_49505 n49505_48993 8.5m
R3056 n3565_3653 n3653_4367 8.5m
R3057 n3565_3653 n3564_3565 8.5m
R3058 n3565_3653 n3565_4367 8.5m
xmem3059 n3565_3653 n3653_3832 l3059 memristor
R3060 n3653_4367 n4367_5104 8.5m
R3061 n3653_4367 n3653_3832 8.5m
R3062 n3653_4367 n3565_4367 8.5m
R3063 n4803_5823 n5823_6118 8.5m
R3064 n4803_5823 n4803_4596 8.5m
R3065 n4803_5823 n5823_6118 8.5m
xmem3066 n4803_5823 n4803_4596 l3066 memristor
R3067 n29587_30057 n30057_30262 8.5m
R3068 n29587_30057 n29503_29587 8.5m
xmem3069 n29587_30057 n30057_30627 l3069 memristor
R3070 n30057_30262 n30262_30366 8.5m
R3071 n30057_30262 n29868_30262 8.5m
R3072 n30057_30262 n30057_30627 8.5m
R3073 n20712_21417 n21034_21417 8.5m
R3074 n20712_21417 n21417_21790 8.5m
R3075 n21034_21417 n21417_21790 8.5m
R3076 n21034_21417 n20936_21034 8.5m
R3077 n3442_3564 n3564_4229 8.5m
R3078 n3442_3564 n3442_3734 8.5m
R3079 n3442_3564 n3252_3442 8.5m
xmem3080 n3442_3564 n3564_3565 l3080 memristor
xmem3081 n3564_4229 n3564_3565 l3081 memristor
xmem3082 n3564_4229 n3734_4229 l3082 memristor
R3083 n38172_38485 n38485_40068 8.5m
xmem3084 n38172_38485 n38485_38484 l3084 memristor
R3085 n16658_18305 n16658_16497 8.5m
R3086 n16658_18305 n18305_18740 8.5m
xmem3087 n16658_18305 n18305_19018 l3087 memristor
R3088 n30624_31248 n31248_31733 8.5m
xmem3089 n30624_31248 n30559_30624 l3089 memristor
R3090 n31248_31733 n31733_31815 8.5m
xmem3091 n31248_31733 n31733_32073 l3091 memristor
xmem3092 n26950_27059 n27059_27479 l3092 memristor
xmem3093 n26950_27059 n27061_27059 l3093 memristor
R3094 n27059_27479 n27311_27479 8.5m
xmem3095 n27059_27479 n27061_27059 l3095 memristor
R3096 n27059_27479 n27479_27823 8.5m
R3097 n10606_12740 n12746_12740 8.5m
R3098 n10606_12740 n12740_13039 8.5m
xmem3099 n10606_12740 n10189_10606 l3099 memristor
R3100 n10606_12740 n10609_10606 8.5m
R3101 n12746_12740 n12746_13299 8.5m
R3102 n12746_12740 n11651_12746 8.5m
R3103 n12746_12740 n12740_13039 8.5m
R3104 n9208_9443 n9443_10594 8.5m
R3105 n9208_9443 n9443_10881 8.5m
xmem3106 n9208_9443 n8643_9208 l3106 memristor
R3107 n9443_10594 n9443_10881 8.5m
xmem3108 n46255_46484 n46484_46780 l3108 memristor
xmem3109 n46255_46484 n46484_46637 l3109 memristor
xmem3110 n14594_16014 n14594_15862 l3110 memristor
R3111 n14594_16014 n16014_16152 8.5m
xmem3112 n14594_16014 n16014_15862 l3112 memristor
xmem3113 n14594_16014 n13905_14594 l3113 memristor
R3114 n14594_15862 n16014_15862 8.5m
xmem3115 n14594_15862 n13905_14594 l3115 memristor
xmem3116 n13567_14704 n14704_15325 l3116 memristor
R3117 n13567_14704 n13108_13567 8.5m
xmem3118 n29164_29161 n29164_29325 l3118 memristor
R3119 n29164_29161 n29161_29863 8.5m
R3120 n29164_29325 n29863_29325 8.5m
R3121 n29164_29325 n29084_29325 8.5m
R3122 n29164_29325 n29164_29161 8.5m
xmem3123 n25366_25588 n25168_25588 l3123 memristor
R3124 n25366_25588 n25366_25305 8.5m
R3125 n25366_25588 n25588_26016 8.5m
R3126 n25366_25588 n24277_25366 8.5m
R3127 n25168_25588 n25588_26016 8.5m
R3128 n25168_25588 n25033_25168 8.5m
R3129 n25168_25588 n25168_26010 8.5m
R3130 n36927_37523 n37523_38119 8.5m
R3131 n36927_37523 n37138_37523 8.5m
R3132 n36927_37523 n36682_36927 8.5m
xmem3133 n36927_37523 n35324_36927 l3133 memristor
R3134 n37523_38119 n37138_37523 8.5m
xmem3135 n37523_38119 n37138_38119 l3135 memristor
R3136 n37523_38119 n38119_38121 8.5m
R3137 n7813_8465 n8465_8758 8.5m
R3138 n7813_8465 n7448_7813 8.5m
xmem3139 n7813_8465 n8625_8465 l3139 memristor
xmem3140 n8465_8758 n8758_11540 l3140 memristor
R3141 n8465_8758 n8625_8465 8.5m
xmem3142 n8465_8758 n8758_11878 l3142 memristor
xmem3143 n24414_25579 n25579_25745 l3143 memristor
xmem3144 n24414_25579 n24137_24414 l3144 memristor
R3145 n24414_25579 n24412_24414 8.5m
xmem3146 n25579_25745 n25745_26704 l3146 memristor
R3147 n25579_25745 n24412_25745 8.5m
R3148 n45663_45734 n45663_47940 8.5m
xmem3149 n42809_43119 n43117_43119 l3149 memristor
R3150 n42809_43119 n42809_43541 8.5m
R3151 n42809_43119 n42387_42809 8.5m
xmem3152 n42809_43119 n43119_43750 l3152 memristor
R3153 n43117_43119 n43117_43479 8.5m
R3154 n43117_43119 n43119_43750 8.5m
R3155 n43117_43119 n42806_43117 8.5m
R3156 n23400_23700 n23297_23700 8.5m
R3157 n36568_36562 n36882_36562 8.5m
xmem3158 n36568_36562 n36425_36562 l3158 memristor
xmem3159 n31464_31526 n31526_31800 l3159 memristor
xmem3160 n18265_18892 n18892_18980 l3160 memristor
R3161 n18265_18892 n18056_18265 8.5m
R3162 n18265_18892 n18050_18265 8.5m
xmem3163 n18265_18892 n18065_18892 l3163 memristor
R3164 n18892_18980 n18980_19289 8.5m
R3165 n18892_18980 n18980_19289 8.5m
R3166 n18892_18980 n18065_18892 8.5m
R3167 n7555_8238 n8238_8925 8.5m
R3168 n7555_8238 n7555_8338 8.5m
xmem3169 n7555_8238 n6812_7555 l3169 memristor
R3170 n7555_8238 n8238_8230 8.5m
R3171 n8238_8925 n8925_10105 8.5m
R3172 n8238_8925 n8238_8230 8.5m
xmem3173 n8238_8925 n8925_11816 l3173 memristor
R3174 n32848_33352 n31818_32848 8.5m
R3175 n32848_33352 n33352_34160 8.5m
xmem3176 n32848_33352 n33352_33346 l3176 memristor
xmem3177 n44060_44655 n44703_44655 l3177 memristor
xmem3178 n53333_53340 n53333_53564 l3178 memristor
R3179 n53333_53340 n52605_53333 8.5m
xmem3180 n53333_53340 n53340_53917 l3180 memristor
xmem3181 n53333_53340 n53026_53340 l3181 memristor
R3182 n53333_53564 n53564_54037 8.5m
R3183 n53333_53564 n52605_53333 8.5m
xmem3184 n31344_31342 n31268_31342 l3184 memristor
xmem3185 n31344_31342 n31344_31481 l3185 memristor
R3186 n31344_31342 n31541_31342 8.5m
R3187 n9615_9533 n9615_10187 8.5m
R3188 n9615_9533 n9107_9533 8.5m
xmem3189 n9615_9533 n8803_9615 l3189 memristor
xmem3190 n9615_10187 n10187_10327 l3190 memristor
xmem3191 n9615_10187 n8803_9615 l3191 memristor
R3192 n36475_37145 n37145_37388 8.5m
R3193 n55183_55372 n55234_55372 8.5m
R3194 n55183_55372 n55183_55236 8.5m
xmem3195 n55183_55372 n55183_55234 l3195 memristor
R3196 n55234_55372 n55183_55234 8.5m
R3197 n15088_15893 n15577_15893 8.5m
R3198 n15088_15893 n15893_16194 8.5m
xmem3199 n15577_15893 n15577_16047 l3199 memristor
xmem3200 n15577_15893 n14781_15577 l3200 memristor
R3201 n15577_15893 n15893_16194 8.5m
xmem3202 n28178_28256 n27672_28256 l3202 memristor
R3203 n28178_28256 n28256_29188 8.5m
R3204 n28178_28256 n27672_28178 8.5m
R3205 n31988_31982 n31988_32344 8.5m
xmem3206 n31988_31982 n31980_31982 l3206 memristor
R3207 n8033_8953 n7567_8033 8.5m
R3208 n34220_36207 n34304_34220 8.5m
R3209 n28766_29284 n28766_29210 8.5m
R3210 n28766_29284 n29284_29210 8.5m
R3211 n15893_16194 n16194_16277 8.5m
R3212 n15893_16194 n15417_16194 8.5m
R3213 n16194_16277 n16460_16277 8.5m
xmem3214 n16194_16277 n15417_16194 l3214 memristor
R3215 n16194_16277 n16276_16277 8.5m
R3216 n33755_34230 n34232_34230 8.5m
R3217 n33755_34230 n33267_33755 8.5m
R3218 n34232_34230 n33685_34232 8.5m
xmem3219 n3695_4399 n4399_4867 l3219 memristor
xmem3220 n3695_4399 n3397_4399 l3220 memristor
xmem3221 n47054_47251 n47251_47443 l3221 memristor
R3222 n47054_47251 n47251_47382 8.5m
R3223 n47054_47251 n47002_47054 8.5m
xmem3224 n47054_47251 n47054_47443 l3224 memristor
R3225 n47251_47443 n47443_47576 8.5m
R3226 n47251_47443 n47054_47443 8.5m
xmem3227 n47251_47443 n47251_47382 l3227 memristor
xmem3228 n6013_6264 n6264_6451 l3228 memristor
xmem3229 n6013_6264 n6013_6077 l3229 memristor
R3230 n6013_6264 n5407_6013 8.5m
R3231 n6013_6264 n6077_6264 8.5m
R3232 n6264_6451 n6259_6451 8.5m
xmem3233 n6264_6451 n6451_6836 l3233 memristor
R3234 n6264_6451 n6077_6264 8.5m
xmem3235 n28152_29084 n29084_29325 l3235 memristor
R3236 n28152_29084 n29084_29170 8.5m
R3237 n29084_29325 n29084_29170 8.5m
R3238 n29084_29325 n29863_29325 8.5m
xmem3239 n45200_45198 n45198_45265 l3239 memristor
R3240 n45200_45198 n45198_45616 8.5m
xmem3241 n45198_45265 n45265_45616 l3241 memristor
R3242 n45198_45265 n45198_45616 8.5m
xmem3243 n45198_45265 n45265_45616 l3243 memristor
R3244 n10327_10720 n10720_11317 8.5m
R3245 n10327_10720 n10187_10327 8.5m
xmem3246 n10327_10720 n10327_12491 l3246 memristor
R3247 n10720_11317 n12491_11317 8.5m
xmem3248 n10720_11317 n11317_11313 l3248 memristor
xmem3249 n19405_19867 n19867_19868 l3249 memristor
R3250 n19405_19867 n19255_19405 8.5m
R3251 n19405_19867 n19405_19868 8.5m
R3252 n19405_19867 n19867_20345 8.5m
xmem3253 n19867_19868 n19405_19868 l3253 memristor
xmem3254 n19867_19868 n19870_19868 l3254 memristor
xmem3255 n19867_19868 n19867_20345 l3255 memristor
R3256 n21747_21973 n21745_21747 8.5m
R3257 n10789_11227 n11227_11637 8.5m
xmem3258 n10789_11227 n10792_10789 l3258 memristor
xmem3259 n10789_11227 n10177_10789 l3259 memristor
xmem3260 n55640_56350 n56350_56863 l3260 memristor
R3261 n55640_56350 n55517_55640 8.5m
R3262 n55640_56350 n55517_55640 8.5m
R3263 n56350_56863 n56863_57021 8.5m
R3264 n56350_56863 n56863_56955 8.5m
R3265 n34551_35032 n35032_35105 8.5m
R3266 n34551_35032 n34551_34622 8.5m
R3267 n20504_21022 n20787_21022 8.5m
R3268 n20504_21022 n19547_20504 8.5m
R3269 n20504_21022 n21022_21207 8.5m
R3270 n20787_21022 n21022_21207 8.5m
R3271 n20787_21022 n20403_20787 8.5m
R3272 n20787_21022 n20398_20787 8.5m
xmem3273 n17171_18373 n18081_18373 l3273 memristor
R3274 n17171_18373 n16721_17171 8.5m
R3275 n17171_18373 n18373_20158 8.5m
xmem3276 n17171_18373 n17171_17568 l3276 memristor
xmem3277 n18081_18373 n18081_18559 l3277 memristor
xmem3278 n18081_18373 n18373_20158 l3278 memristor
R3279 n18081_18373 n17957_18081 8.5m
R3280 n22016_22211 n22211_22481 8.5m
xmem3281 n22016_22211 n22211_22371 l3281 memristor
xmem3282 n22016_22211 n21945_22016 l3282 memristor
xmem3283 n22211_22481 n22481_22371 l3283 memristor
R3284 n22211_22481 n22581_22481 8.5m
xmem3285 n22211_22481 n22211_22371 l3285 memristor
xmem3286 n18516_18690 n18690_19516 l3286 memristor
xmem3287 n18516_18690 n17819_18516 l3287 memristor
R3288 n18516_18690 n18690_19046 8.5m
xmem3289 n18690_19516 n18690_19046 l3289 memristor
xmem3290 n18690_19516 n19516_20107 l3290 memristor
R3291 n18690_19516 n19046_19516 8.5m
R3292 n22508_23377 n23377_23378 8.5m
xmem3293 n22508_23377 n23377_23577 l3293 memristor
R3294 n22508_23377 n21745_22508 8.5m
R3295 n23377_23378 n23377_23577 8.5m
xmem3296 n24828_26527 n26527_26752 l3296 memristor
R3297 n24828_26527 n24837_24828 8.5m
xmem3298 n24828_26527 n24633_24828 l3298 memristor
R3299 n24828_26527 n26653_26527 8.5m
R3300 n26527_26752 n26653_26527 8.5m
R3301 n26527_26752 n26743_26752 8.5m
R3302 n13154_13446 n13442_13446 8.5m
R3303 n13154_13446 n13159_13154 8.5m
R3304 n13154_13446 n13011_13154 8.5m
R3305 n13154_13446 n13446_15538 8.5m
xmem3306 n13442_13446 n13446_15538 l3306 memristor
R3307 n13442_13446 n13442_13816 8.5m
R3308 n18871_19656 n19656_19650 8.5m
R3309 n19656_19650 n19650_19951 8.5m
xmem3310 n19656_19650 n19260_19650 l3310 memristor
R3311 n47137_47875 n47875_48318 8.5m
R3312 n47137_47875 n47875_48031 8.5m
xmem3313 n29049_29051 n29049_29750 l3313 memristor
R3314 n29049_29051 n29051_29458 8.5m
xmem3315 n29049_29051 n24525_29049 l3315 memristor
xmem3316 n29049_29051 n29051_29685 l3316 memristor
xmem3317 n29049_29750 n24525_29049 l3317 memristor
R3318 n26125_26985 n26985_27269 8.5m
xmem3319 n26125_26985 n26985_26800 l3319 memristor
xmem3320 n26125_26985 n25589_26125 l3320 memristor
xmem3321 n26125_26985 n26125_26019 l3321 memristor
R3322 n26985_27269 n26985_26800 8.5m
R3323 n26985_27269 n27269_27515 8.5m
R3324 n26985_27269 n27269_27723 8.5m
R3325 n32538_32446 n32446_32773 8.5m
xmem3326 n32538_32446 n32085_32538 l3326 memristor
R3327 n32538_32446 n32538_32773 8.5m
R3328 n32446_32773 n32538_32773 8.5m
R3329 n32446_32773 n32357_32773 8.5m
xmem3330 n21011_21191 n20778_21191 l3330 memristor
R3331 n25745_26704 n25916_26704 8.5m
xmem3332 n25745_26704 n26704_27715 l3332 memristor
R3333 n25745_26704 n24412_25745 8.5m
R3334 n3442_3734 n3734_4229 8.5m
R3335 n3442_3734 n3561_3734 8.5m
xmem3336 n3442_3734 n3252_3442 l3336 memristor
xmem3337 n3734_4229 n3561_3734 l3337 memristor
xmem3338 n31818_32848 n31818_33115 l3338 memristor
R3339 n31818_32848 n31668_31818 8.5m
R3340 n54740_55144 n55144_56506 8.5m
R3341 n137_223 n223_234 8.5m
R3342 n35788_35787 n35787_36425 8.5m
R3343 n35788_35787 n35695_35787 8.5m
xmem3344 n13868_14214 n13965_14214 l3344 memristor
xmem3345 n13868_14214 n13401_13868 l3345 memristor
xmem3346 n13868_14214 n13580_13868 l3346 memristor
xmem3347 n16081_16878 n16878_21954 l3347 memristor
xmem3348 n16081_16878 n16878_16863 l3348 memristor
xmem3349 n16878_21954 n21954_21958 l3349 memristor
R3350 n16878_21954 n16878_16863 8.5m
xmem3351 n16878_21954 n21954_22691 l3351 memristor
R3352 n18948_20354 n20354_19874 8.5m
R3353 n18948_20354 n20354_20576 8.5m
R3354 n18948_20354 n18949_18948 8.5m
xmem3355 n20354_19874 n20354_20576 l3355 memristor
R3356 n20354_19874 n19874_19802 8.5m
R3357 n20354_19874 n18949_19874 8.5m
R3358 n25023_25094 n25094_27081 8.5m
R3359 n25023_25094 n25094_26234 8.5m
xmem3360 n5424_5686 n5685_5686 l3360 memristor
R3361 n5424_5686 n5202_5424 8.5m
R3362 n5424_5686 n5685_5686 8.5m
R3363 n5424_5686 n5202_5424 8.5m
R3364 n53645_53831 n52562_53645 8.5m
xmem3365 n53645_53831 n53645_53649 l3365 memristor
R3366 n11066_11172 n11172_11651 8.5m
R3367 n11066_11172 n10620_11066 8.5m
R3368 n11066_11172 n10613_11066 8.5m
R3369 n11172_11651 n11651_12746 8.5m
R3370 n11172_11651 n11652_11651 8.5m
xmem3371 n28619_28195 n27630_28195 l3371 memristor
R3372 n28619_28195 n28195_28284 8.5m
R3373 n28619_28195 n27228_28619 8.5m
R3374 n52807_53084 n53086_53084 8.5m
R3375 n53086_53084 n53086_53275 8.5m
R3376 n53086_53084 n52613_53086 8.5m
xmem3377 n43570_43573 n43570_43782 l3377 memristor
xmem3378 n43570_43573 n43573_43656 l3378 memristor
R3379 n27883_28280 n28280_28688 8.5m
xmem3380 n27883_28280 n27687_27883 l3380 memristor
xmem3381 n27883_28280 n27883_28192 l3381 memristor
R3382 n27883_28280 n28280_28284 8.5m
R3383 n28280_28688 n28192_28688 8.5m
R3384 n28280_28688 n28688_29385 8.5m
R3385 n28280_28688 n28280_28284 8.5m
R3386 n7072_11788 n11788_11885 8.5m
R3387 n7072_11788 n7074_7072 8.5m
R3388 n7072_11788 n6604_7072 8.5m
R3389 n7072_11788 n11788_11882 8.5m
R3390 n11788_11885 n11885_12379 8.5m
R3391 n11788_11885 n11788_11882 8.5m
R3392 n32911_32913 n32913_34571 8.5m
R3393 n32911_32913 n32250_32913 8.5m
R3394 n32913_34571 n32250_32913 8.5m
R3395 n32913_34571 n34501_34571 8.5m
R3396 n20576_21083 n20354_20576 8.5m
R3397 n20576_21083 n20470_20576 8.5m
R3398 n20576_21083 n21083_20764 8.5m
xmem3399 n10338_10196 n9948_10196 l3399 memristor
R3400 n10338_10196 n4163_10338 8.5m
R3401 n40647_40752 n40752_41252 8.5m
R3402 n40647_40752 n40752_40826 8.5m
R3403 n40647_40752 n39701_40647 8.5m
R3404 n40752_41252 n41252_41253 8.5m
R3405 n40752_41252 n40752_40826 8.5m
xmem3406 n16589_16671 n16589_16580 l3406 memristor
R3407 n16589_16671 n16671_16955 8.5m
R3408 n16589_16671 n16671_16593 8.5m
xmem3409 n4836_5202 n5202_5424 l3409 memristor
R3410 n4836_5202 n4095_4836 8.5m
R3411 n4836_5202 n5202_5690 8.5m
R3412 n4836_5202 n4836_4949 8.5m
R3413 n5202_5424 n5202_5690 8.5m
R3414 n24730_25125 n25125_25258 8.5m
R3415 n24730_25125 n24443_24730 8.5m
R3416 n24730_25125 n24986_25125 8.5m
R3417 n24730_25125 n24528_24730 8.5m
xmem3418 n25125_25258 n25258_26629 l3418 memristor
R3419 n25125_25258 n24986_25125 8.5m
xmem3420 n25125_25258 n24986_25258 l3420 memristor
xmem3421 vin n31451_31647 l3421 memristor
xmem3422 n20764_20981 n20981_21739 l3422 memristor
R3423 n20764_20981 n21083_20764 8.5m
R3424 n49203_49610 n49610_49811 8.5m
xmem3425 n49203_49610 n48882_49203 l3425 memristor
xmem3426 n49203_49610 n49203_49486 l3426 memristor
R3427 n49203_49610 n49610_49605 8.5m
R3428 n49610_49811 n49616_49811 8.5m
xmem3429 n49610_49811 n49610_49605 l3429 memristor
R3430 n49610_49811 n49811_50349 8.5m
R3431 n33332_35344 n35344_35348 8.5m
R3432 n33332_35344 n32837_33332 8.5m
R3433 n33332_35344 n34916_35344 8.5m
xmem3434 n33332_35344 n33332_33328 l3434 memristor
R3435 n35344_35348 n34917_35348 8.5m
xmem3436 n35344_35348 n34916_35344 l3436 memristor
xmem3437 n35344_35348 n35348_35506 l3437 memristor
xmem3438 n19528_19911 n19911_20845 l3438 memristor
xmem3439 n19528_19911 n19911_21395 l3439 memristor
xmem3440 n19911_20845 n20497_20845 l3440 memristor
R3441 n19911_20845 n20845_21194 8.5m
xmem3442 n19911_20845 n19911_21395 l3442 memristor
R3443 n27061_27059 n27061_27313 8.5m
xmem3444 n27061_27313 n27313_27823 l3444 memristor
R3445 n27061_27313 n27564_27313 8.5m
R3446 n53007_53599 n53003_53007 8.5m
xmem3447 n53007_53599 n53544_53599 l3447 memristor
R3448 n53007_53599 n53599_53901 8.5m
R3449 n39308_39652 n39652_40441 8.5m
R3450 n39308_39652 n39652_39825 8.5m
xmem3451 n39308_39652 n39308_39485 l3451 memristor
R3452 n39652_40441 n39825_40441 8.5m
R3453 n39652_40441 n39652_39825 8.5m
xmem3454 n39652_40441 n40441_40198 l3454 memristor
xmem3455 n7802_8127 n8127_9384 l3455 memristor
R3456 n7802_8127 n7427_7802 8.5m
R3457 n8127_9384 n9384_9727 8.5m
R3458 n8127_9384 n9384_10064 8.5m
R3459 n8127_9384 n7802_8127 8.5m
xmem3460 n58255_58378 n58378_58482 l3460 memristor
xmem3461 n29863_29325 n29161_29863 l3461 memristor
R3462 n31289_31426 n31426_32022 8.5m
R3463 n31289_31426 n31130_31289 8.5m
xmem3464 n31289_31426 n31206_31426 l3464 memristor
xmem3465 n21452_21958 n21958_23365 l3465 memristor
R3466 n21452_21958 n21954_21958 8.5m
R3467 n21958_23365 n21954_21958 8.5m
R3468 n2115_3252 n3252_3442 8.5m
R3469 n2115_3252 n3252_3561 8.5m
R3470 n2115_3252 n2115_2274 8.5m
R3471 n2115_3252 n2115_2274 8.5m
R3472 n3252_3442 n3252_3561 8.5m
R3473 n43570_43782 n43709_43782 8.5m
R3474 n37237_37330 n37330_38138 8.5m
xmem3475 n37237_37330 n36043_37237 l3475 memristor
xmem3476 n37237_37330 n37330_39513 l3476 memristor
R3477 n37237_37330 n37237_37328 8.5m
R3478 n37330_38138 n37330_39513 8.5m
xmem3479 n37330_38138 n37328_38138 l3479 memristor
xmem3480 n42809_43541 n42387_42809 l3480 memristor
R3481 n42809_43541 n42569_43541 8.5m
xmem3482 n42809_43541 n43541_43750 l3482 memristor
xmem3483 n53086_53275 n53275_53514 l3483 memristor
R3484 n53086_53275 n52736_53275 8.5m
R3485 n53086_53275 n52613_53086 8.5m
xmem3486 n35006_35272 n35272_35436 l3486 memristor
R3487 n35006_35272 n31754_35006 8.5m
xmem3488 n16445_16177 n16445_17026 l3488 memristor
R3489 n16445_16177 n15804_16177 8.5m
R3490 n16445_16177 n15231_16445 8.5m
xmem3491 n16445_17026 n15231_16445 l3491 memristor
R3492 n33372_33927 n33259_33372 8.5m
xmem3493 n33372_33927 n33372_33614 l3493 memristor
xmem3494 n30559_30624 n30140_30559 l3494 memristor
R3495 n23499_24364 n24364_24837 8.5m
R3496 n23499_24364 n23405_23499 8.5m
R3497 n23499_24364 n24364_24470 8.5m
R3498 n24364_24837 n24837_24828 8.5m
R3499 n24364_24837 n24364_24470 8.5m
xmem3500 n19260_19650 n19650_19951 l3500 memristor
xmem3501 n19650_19951 n19951_20256 l3501 memristor
R3502 n19650_19951 n19870_19951 8.5m
R3503 n14074_14485 n14485_14484 8.5m
R3504 n14074_14485 n13523_14074 8.5m
R3505 n14074_14485 n14485_14736 8.5m
xmem3506 n14485_14484 n14485_14736 l3506 memristor
R3507 n14485_14484 n14232_14484 8.5m
R3508 n14485_14484 n14232_14484 8.5m
R3509 n35767_36041 n35767_36043 8.5m
R3510 n35767_36041 n35506_36041 8.5m
R3511 n35767_36041 n35260_35767 8.5m
xmem3512 n35767_36041 n36041_36043 l3512 memristor
R3513 n35767_36043 n36043_37237 8.5m
R3514 n35767_36043 n35260_35767 8.5m
R3515 n35767_36043 n36041_36043 8.5m
xmem3516 n43119_43750 n43541_43750 l3516 memristor
R3517 n43541_43750 n42569_43541 8.5m
R3518 n4795_5543 n4596_4795 8.5m
R3519 n4795_5543 n5543_6307 8.5m
R3520 n4795_5543 n5543_6307 8.5m
xmem3521 n4795_5543 n4596_4795 l3521 memristor
R3522 n16262_17346 n17346_17033 8.5m
R3523 n3561_3730 n3561_3734 8.5m
R3524 n3561_3730 n3252_3561 8.5m
xmem3525 n3473_3476 n2990_3476 l3525 memristor
R3526 n3473_3476 n3476_3534 8.5m
xmem3527 n3473_3476 n3473_4120 l3527 memristor
xmem3528 n2990_3476 n3476_3534 l3528 memristor
xmem3529 n9971_10451 n10451_11349 l3529 memristor
R3530 n9971_10451 n9727_9971 8.5m
xmem3531 n9971_10451 n10064_9971 l3531 memristor
R3532 n13765_14276 n14276_14350 8.5m
xmem3533 n32565_32888 n32891_32888 l3533 memristor
R3534 n24219_24277 n24277_25366 8.5m
R3535 n24219_24277 n24219_24970 8.5m
R3536 n24219_24277 n23755_24277 8.5m
xmem3537 n24219_24277 n23075_24219 l3537 memristor
xmem3538 n24277_25366 n25366_25305 l3538 memristor
xmem3539 n24277_25366 n23755_24277 l3539 memristor
R3540 n22174_22245 n22245_22421 8.5m
xmem3541 n22174_22245 n22174_21003 l3541 memristor
xmem3542 n22174_22245 n22245_22725 l3542 memristor
R3543 n22174_22245 n22174_22924 8.5m
R3544 n22245_22421 n22421_22725 8.5m
R3545 n22245_22421 n22820_22421 8.5m
R3546 n22245_22421 n22245_22725 8.5m
xmem3547 n39560_39562 n39560_39825 l3547 memristor
R3548 n39560_39562 n39562_40203 8.5m
R3549 n39560_39562 n39562_39661 8.5m
xmem3550 n39560_39825 n39652_39825 l3550 memristor
R3551 n39560_39825 n39825_40441 8.5m
R3552 n21747_21973 n21745_21747 8.5m
xmem3553 n33553_34119 n34119_33626 l3553 memristor
R3554 n33553_34119 n33557_33553 8.5m
xmem3555 n33553_34119 n33386_33553 l3555 memristor
R3556 n4949_5685 n4836_4949 8.5m
R3557 n4949_5685 n5685_5686 8.5m
R3558 n14387_14487 n14487_15683 8.5m
R3559 n17107_17467 n17867_17467 8.5m
R3560 n17107_17467 n17329_17107 8.5m
R3561 n17107_17467 n17467_17799 8.5m
R3562 n17107_17467 n16953_17107 8.5m
R3563 n17867_17467 n17867_17980 8.5m
R3564 n17867_17467 n16955_17867 8.5m
xmem3565 n17867_17467 n17467_17799 l3565 memristor
R3566 n26444_27571 n27571_28495 8.5m
R3567 n26444_27571 n26438_26444 8.5m
R3568 n26444_27571 n26087_26444 8.5m
xmem3569 n22663_22855 n22855_23549 l3569 memristor
xmem3570 n22663_22855 n22663_22560 l3570 memristor
xmem3571 n22663_22855 n22851_22855 l3571 memristor
R3572 n22855_23549 n22851_23549 8.5m
xmem3573 n22855_23549 n23549_23834 l3573 memristor
R3574 n22855_23549 n22851_22855 8.5m
R3575 n9426_8776 n9426_10173 8.5m
R3576 n9426_8776 n8773_8776 8.5m
xmem3577 n5104_5476 n5476_5898 l3577 memristor
xmem3578 n5104_5476 n4367_5104 l3578 memristor
R3579 n5104_5476 n5104_5107 8.5m
xmem3580 n5104_5476 n5103_5476 l3580 memristor
xmem3581 n5476_5898 n5898_7094 l3581 memristor
R3582 n5476_5898 n5103_5476 8.5m
R3583 n28910_28600 n28600_28756 8.5m
xmem3584 n28910_28600 n29188_28910 l3584 memristor
R3585 n28910_28600 n28321_28910 8.5m
xmem3586 n28600_28756 n28756_29523 l3586 memristor
xmem3587 n28600_28756 n28756_29822 l3587 memristor
xmem3588 n21127_21210 n21210_21306 l3588 memristor
xmem3589 n21127_21210 n21210_21306 l3589 memristor
R3590 n20305_21122 n20305_20403 8.5m
R3591 n20305_21122 n19449_20305 8.5m
R3592 n30186_32923 n32923_33310 8.5m
R3593 n30186_32923 n32923_33310 8.5m
R3594 n5407_6013 n6013_6077 8.5m
R3595 n23435_24768 n24768_25562 8.5m
R3596 n23435_24768 n22940_23435 8.5m
xmem3597 n23435_24768 n23435_23522 l3597 memristor
xmem3598 n24768_25562 n25562_25636 l3598 memristor
R3599 n24768_25562 n24863_25562 8.5m
R3600 n52610_53028 n53026_53028 8.5m
xmem3601 n25265_25809 n25809_27687 l3601 memristor
xmem3602 n25265_25809 n25265_25622 l3602 memristor
xmem3603 n25265_25809 n24935_25265 l3603 memristor
xmem3604 n25809_27687 n27687_27883 l3604 memristor
xmem3605 n25809_27687 n27687_26656 l3605 memristor
R3606 n22481_22371 n22581_22481 8.5m
xmem3607 n22481_22371 n22211_22371 l3607 memristor
R3608 n22481_22371 n22371_22374 8.5m
R3609 n21022_21207 n21207_25473 8.5m
R3610 n11540_11690 n11690_12458 8.5m
R3611 n11540_11690 n8758_11540 8.5m
R3612 n31426_32022 n31206_32022 8.5m
xmem3613 n31426_32022 n31206_31426 l3613 memristor
xmem3614 n11184_11585 n11404_11585 l3614 memristor
R3615 n22780_23358 n23358_23755 8.5m
xmem3616 n22780_23358 n22780_23075 l3616 memristor
R3617 gnd n43777_43843 8.5m
xmem3618 gnd n43709_43843 l3618 memristor
R3619 n19140_19220 n19140_19434 8.5m
R3620 n19140_19220 n19220_20497 8.5m
R3621 n19140_19220 n19220_19434 8.5m
R3622 n19140_19220 n19140_19208 8.5m
R3623 n19140_19434 n19140_19208 8.5m
xmem3624 n19140_19434 n19220_19434 l3624 memristor
xmem3625 n19035_19036 n19035_19339 l3625 memristor
R3626 n19035_19036 n18175_19035 8.5m
R3627 n19035_19036 n19036_19732 8.5m
R3628 n19035_19036 n18761_19036 8.5m
R3629 n19035_19339 n19339_19881 8.5m
R3630 n19035_19339 n19338_19339 8.5m
R3631 n19035_19339 n18175_19035 8.5m
R3632 n36068_36313 n36313_36721 8.5m
R3633 n36068_36313 n35529_36068 8.5m
xmem3634 n36068_36313 n35537_36313 l3634 memristor
R3635 n36313_36721 n36311_36721 8.5m
R3636 n36313_36721 n36721_38872 8.5m
R3637 n36313_36721 n35537_36313 8.5m
xmem3638 n43812_44604 n44604_45170 l3638 memristor
R3639 n43812_44604 n43535_43812 8.5m
R3640 n43812_44604 n44471_44604 8.5m
xmem3641 n44604_45170 n44471_44604 l3641 memristor
R3642 n44604_45170 n45170_46623 8.5m
R3643 n44604_45170 n44531_45170 8.5m
R3644 n34917_35348 n34917_34916 8.5m
xmem3645 n34917_35348 n35348_35506 l3645 memristor
R3646 n46574_46728 n46728_47120 8.5m
xmem3647 n46574_46728 n46574_47259 l3647 memristor
xmem3648 n46574_46728 n46309_46728 l3648 memristor
xmem3649 n24364_24470 n24470_24637 l3649 memristor
xmem3650 n24364_24470 n24241_24470 l3650 memristor
R3651 n24470_24637 n24241_24470 8.5m
R3652 n24470_24637 n24648_24637 8.5m
xmem3653 n11268_12525 n12525_13418 l3653 memristor
R3654 n23433_23522 n23522_24859 8.5m
xmem3655 n23433_23522 n22940_23433 l3655 memristor
R3656 n23433_23522 n23435_23522 8.5m
R3657 n23433_23522 n23429_23433 8.5m
xmem3658 n23522_24859 n24859_26212 l3658 memristor
xmem3659 n23522_24859 n23435_23522 l3659 memristor
R3660 n23522_24859 n24859_24663 8.5m
xmem3661 n14489_15111 n14316_14489 l3661 memristor
xmem3662 n14489_15111 n13813_14489 l3662 memristor
R3663 n14489_15111 n15111_15444 8.5m
xmem3664 n34501_34571 n32250_34501 l3664 memristor
R3665 n58082_58140 n58140_58363 8.5m
R3666 n17875_18421 n18421_18767 8.5m
R3667 n17875_18421 n17875_18767 8.5m
R3668 n17875_18421 n17728_17875 8.5m
R3669 n18421_18767 n18767_19122 8.5m
xmem3670 n18421_18767 n17875_18767 l3670 memristor
R3671 n21696_21790 n21790_22120 8.5m
xmem3672 n21696_21790 n21696_21777 l3672 memristor
R3673 n21696_21790 n21417_21790 8.5m
R3674 n21696_21790 n21310_21696 8.5m
xmem3675 n21790_22120 n21417_21790 l3675 memristor
R3676 n21790_22120 n22120_22542 8.5m
R3677 n24299_24991 n24991_25193 8.5m
xmem3678 n24299_24991 n24090_24299 l3678 memristor
R3679 n24299_24991 n24448_24991 8.5m
R3680 n24299_24991 n24299_24448 8.5m
R3681 n24991_25193 n24534_25193 8.5m
xmem3682 n24991_25193 n24448_24991 l3682 memristor
R3683 n40449_40563 n40563_40796 8.5m
xmem3684 n40449_40563 n39910_40449 l3684 memristor
R3685 n40449_40563 n40345_40563 8.5m
R3686 n40563_40796 n40345_40563 8.5m
R3687 n40563_40796 n40796_40891 8.5m
xmem3688 n40563_40796 n40796_40891 l3688 memristor
R3689 n33332_33328 n33328_35140 8.5m
R3690 n33332_33328 n32837_33332 8.5m
xmem3691 n33328_35140 n35139_35140 l3691 memristor
R3692 n33328_35140 n35139_35140 8.5m
R3693 n16014_15862 n16014_16152 8.5m
xmem3694 n14437_15231 n15231_15804 l3694 memristor
xmem3695 n14437_15231 n14194_14437 l3695 memristor
R3696 n14437_15231 n15231_16445 8.5m
xmem3697 n14437_15231 n14193_14437 l3697 memristor
xmem3698 n15231_15804 n15804_16177 l3698 memristor
xmem3699 n15231_15804 n15231_16445 l3699 memristor
xmem3700 n24986_25125 n24986_25258 l3700 memristor
xmem3701 n24986_25125 n24528_24986 l3701 memristor
xmem3702 n24986_25258 n24528_24986 l3702 memristor
R3703 n24986_25258 n25258_26629 8.5m
R3704 n18221_19239 n18846_19239 8.5m
xmem3705 n18221_19239 n18221_18846 l3705 memristor
R3706 n18221_19239 n19239_19571 8.5m
xmem3707 n18221_19239 n15683_18221 l3707 memristor
xmem3708 n18846_19239 n19239_19571 l3708 memristor
xmem3709 n18846_19239 n18221_18846 l3709 memristor
R3710 n18846_19239 n18846_19571 8.5m
xmem3711 n6769_7113 n7113_7578 l3711 memristor
R3712 n35577_35324 n35324_36927 8.5m
R3713 n35577_35324 n35577_36682 8.5m
R3714 n13962_14284 n14284_14359 8.5m
R3715 n13962_14284 n13490_13962 8.5m
R3716 n13962_14284 n13864_14284 8.5m
xmem3717 n14284_14359 n13864_14284 l3717 memristor
R3718 n35139_35140 n35139_35665 8.5m
R3719 n35139_35665 n35139_35140 8.5m
xmem3720 n31192_33989 n33989_35441 l3720 memristor
R3721 n31192_33989 n33989_35441 8.5m
xmem3722 n31192_33989 n31192_31606 l3722 memristor
xmem3723 n31192_33989 n30646_31192 l3723 memristor
xmem3724 n10349_10350 n10051_10350 l3724 memristor
xmem3725 n10349_10350 n9550_10349 l3725 memristor
R3726 n10349_10350 n10350_11003 8.5m
xmem3727 n10349_10350 n9628_10349 l3727 memristor
xmem3728 n10051_10350 n10350_11003 l3728 memristor
R3729 n44072_44471 n43333_44072 8.5m
R3730 n44072_44471 n44471_44604 8.5m
R3731 n44072_44471 n44471_44531 8.5m
R3732 n38743_39003 n39003_39437 8.5m
R3733 n38743_39003 n38743_38739 8.5m
xmem3734 n38743_39003 n39003_39787 l3734 memristor
R3735 n38743_39003 n38054_38743 8.5m
R3736 n39003_39437 n39437_39787 8.5m
xmem3737 n39003_39437 n39003_39787 l3737 memristor
xmem3738 n27264_27094 n27264_27515 l3738 memristor
R3739 n27264_27094 n26710_27094 8.5m
R3740 n27264_27094 n26603_27264 8.5m
xmem3741 n27264_27515 n27269_27515 l3741 memristor
xmem3742 n27264_27515 n26603_27264 l3742 memristor
xmem3743 n11227_11637 n11041_11637 l3743 memristor
R3744 n45992_46395 n45994_46395 8.5m
xmem3745 n6013_6077 n6077_6264 l3745 memristor
xmem3746 n23687_24443 n24443_24525 l3746 memristor
xmem3747 n23687_24443 n23095_23687 l3747 memristor
R3748 n23687_24443 n24443_24730 8.5m
R3749 n23687_24443 n23691_23687 8.5m
xmem3750 n24443_24525 n24525_29049 l3750 memristor
R3751 n24443_24525 n24443_24730 8.5m
R3752 n24443_24525 n24524_24525 8.5m
R3753 n39825_40441 n39652_39825 8.5m
xmem3754 n39825_40441 n40441_40198 l3754 memristor
R3755 n48057_48337 n48264_48337 8.5m
xmem3756 n48057_48337 n48057_48272 l3756 memristor
R3757 n48057_48337 n46604_48057 8.5m
xmem3758 n48057_48337 n48264_48337 l3758 memristor
xmem3759 n48264_48337 n46604_48264 l3759 memristor
R3760 n13011_13154 n13159_13154 8.5m
R3761 n39030_39101 n39101_39629 8.5m
R3762 n39030_39101 n37204_39030 8.5m
xmem3763 n435_496 n435_588 l3763 memristor
xmem3764 n435_496 n496_994 l3764 memristor
R3765 n435_588 n435_496 8.5m
xmem3766 n435_588 n588_633 l3766 memristor
R3767 n435_588 n588_993 8.5m
R3768 n21509_22630 n22630_24384 8.5m
R3769 n21509_22630 n21403_21509 8.5m
R3770 n22630_24384 n24384_25816 8.5m
xmem3771 n32891_32640 n32640_32657 l3771 memristor
xmem3772 n32891_32640 n32891_32888 l3772 memristor
R3773 n32891_32640 n32229_32891 8.5m
R3774 n32891_32640 n32229_32640 8.5m
R3775 n32640_32657 n32657_32903 8.5m
R3776 n32640_32657 n32229_32640 8.5m
xmem3777 n31754_35006 n31606_31754 l3777 memristor
xmem3778 n31754_35006 n31750_31754 l3778 memristor
xmem3779 n33744_33931 n33614_33931 l3779 memristor
R3780 n33744_33931 n33855_33744 8.5m
R3781 n33744_33931 n33614_33744 8.5m
R3782 n12525_13418 n11268_12525 8.5m
xmem3783 n23347_25033 n25033_25168 l3783 memristor
R3784 n23347_25033 n25033_23911 8.5m
R3785 n25033_25168 n25033_23911 8.5m
xmem3786 n25033_25168 n25168_26010 l3786 memristor
R3787 n25094_27081 n26697_27081 8.5m
xmem3788 n25094_27081 n25094_26234 l3788 memristor
xmem3789 n26697_27081 n26697_26863 l3789 memristor
xmem3790 n37138_37523 n37138_38119 l3790 memristor
R3791 n37138_37523 n36682_37138 8.5m
R3792 n37138_38119 n36682_37138 8.5m
R3793 n37138_38119 n38119_38121 8.5m
xmem3794 n23075_23755 n23755_24277 l3794 memristor
xmem3795 n23075_23755 n23358_23755 l3795 memristor
xmem3796 n23075_23755 n22780_23075 l3796 memristor
xmem3797 n23075_23755 n23075_24219 l3797 memristor
R3798 n23755_24277 n23358_23755 8.5m
R3799 n52790_52935 n52935_53196 8.5m
R3800 n16677_17273 n16518_16677 8.5m
xmem3801 n16677_17273 n16677_17272 l3801 memristor
xmem3802 n18759_18949 n18759_19338 l3802 memristor
R3803 n18759_18949 n18949_19874 8.5m
xmem3804 n18759_18949 n18949_18948 l3804 memristor
R3805 n18759_18949 n17531_18759 8.5m
R3806 n18759_19338 n19338_19802 8.5m
xmem3807 n18759_19338 n17531_18759 l3807 memristor
R3808 n18759_19338 n19338_19339 8.5m
R3809 n18175_19035 n18175_18761 8.5m
R3810 n34093_35903 n34092_34093 8.5m
R3811 n34093_35903 n34006_34093 8.5m
R3812 n43984_43886 n43270_43984 8.5m
R3813 n43984_43886 n43984_44240 8.5m
xmem3814 n20078_21242 n20078_21717 l3814 memristor
xmem3815 n20078_21242 n19571_20078 l3815 memristor
xmem3816 n20078_21242 n21242_21717 l3816 memristor
xmem3817 n20078_21242 n21242_21246 l3817 memristor
xmem3818 n20078_21717 n21242_21717 l3818 memristor
R3819 n20078_21717 n19571_20078 8.5m
xmem3820 n20078_21717 n21717_22364 l3820 memristor
R3821 n7528_7599 n7599_8316 8.5m
R3822 n19713_20340 n20340_21060 8.5m
xmem3823 n19713_20340 n19093_19713 l3823 memristor
R3824 n20340_21060 n21060_21074 8.5m
R3825 n15134_15794 n15794_16097 8.5m
R3826 n15134_15794 n15794_15476 8.5m
xmem3827 n15134_15794 n15145_15134 l3827 memristor
xmem3828 n15134_15794 n15133_15134 l3828 memristor
R3829 n15794_16097 n16097_16580 8.5m
xmem3830 n15794_16097 n15794_15476 l3830 memristor
xmem3831 n10286_10287 n10652_10286 l3831 memristor
xmem3832 n10286_10287 n10652_10286 l3832 memristor
R3833 n19338_19802 n19874_19802 8.5m
xmem3834 n19338_19802 n19802_20470 l3834 memristor
xmem3835 n19338_19802 n19338_19339 l3835 memristor
xmem3836 n19874_19802 n18949_19874 l3836 memristor
R3837 n19874_19802 n19802_20470 8.5m
R3838 n22940_23435 n23435_23522 8.5m
xmem3839 n22940_23435 n22940_23433 l3839 memristor
R3840 n22940_23435 n22742_22940 8.5m
R3841 n52102_52349 n52349_53279 8.5m
R3842 n52102_52349 n51547_52102 8.5m
xmem3843 n52102_52349 n52102_51742 l3843 memristor
R3844 n52102_52349 n51615_52349 8.5m
R3845 n52349_53279 n52533_53279 8.5m
R3846 n52349_53279 n51615_52349 8.5m
R3847 n9227_9034 n9227_9456 8.5m
R3848 n9227_9034 n8510_9034 8.5m
R3849 n9227_9034 n9034_8940 8.5m
R3850 n9227_9034 n7945_9227 8.5m
R3851 n9227_9456 n9461_9456 8.5m
R3852 n9227_9456 n9456_10026 8.5m
xmem3853 n9227_9456 n7945_9227 l3853 memristor
xmem3854 n39308_39485 n39485_40107 l3854 memristor
R3855 n39308_39485 n39297_39485 8.5m
xmem3856 n12870_13271 n13271_14029 l3856 memristor
xmem3857 n12870_13271 n12870_13266 l3857 memristor
R3858 n12870_13271 n12645_12870 8.5m
xmem3859 n12870_13271 n13271_13266 l3859 memristor
xmem3860 n13271_14029 n14029_13924 l3860 memristor
xmem3861 n13271_14029 n14029_13924 l3861 memristor
R3862 n13271_14029 n13271_13266 8.5m
R3863 n31541_31750 n31481_31750 8.5m
xmem3864 n31541_31750 n31750_31754 l3864 memristor
R3865 n31541_31750 n31541_31342 8.5m
R3866 n31541_31750 n31267_31541 8.5m
R3867 n31481_31750 n31344_31481 8.5m
xmem3868 n31481_31750 n31750_31754 l3868 memristor
R3869 n31481_31750 n31481_31606 8.5m
R3870 n34453_34622 n34551_34622 8.5m
R3871 n34453_34622 n33386_34453 8.5m
xmem3872 n39593_39229 n39068_39229 l3872 memristor
R3873 n18081_18559 n17957_18081 8.5m
R3874 n15093_15749 n15749_15342 8.5m
R3875 n15093_15749 n12603_15093 8.5m
xmem3876 n15093_15749 n15093_15342 l3876 memristor
xmem3877 n15749_15342 n15093_15342 l3877 memristor
R3878 n47875_48318 n47875_48031 8.5m
R3879 n47875_48318 n48318_48701 8.5m
xmem3880 n47875_48318 n48318_48405 l3880 memristor
xmem3881 n23095_23687 n23691_23687 l3881 memristor
R3882 n23691_23687 n23691_24528 8.5m
xmem3883 n25258_26629 n26632_26629 l3883 memristor
xmem3884 n25258_26629 n26629_29126 l3884 memristor
R3885 n26632_26629 n26629_29126 8.5m
xmem3886 n26632_26629 n26398_26632 l3886 memristor
R3887 n26632_26629 n26398_26632 8.5m
R3888 n31093_31258 n31094_31258 8.5m
R3889 n4818_5019 n5019_5112 8.5m
xmem3890 n4818_5019 n5324_5019 l3890 memristor
xmem3891 n4818_5019 n4372_4818 l3891 memristor
R3892 n4818_5019 n4818_4812 8.5m
R3893 n5019_5112 n5112_6069 8.5m
R3894 n5019_5112 n5112_6317 8.5m
R3895 n5019_5112 n5324_5019 8.5m
xmem3896 n35529_35537 n35537_36313 l3896 memristor
xmem3897 n35529_35537 n35529_36068 l3897 memristor
R3898 n28215_28057 n28057_28417 8.5m
R3899 n28215_28057 n28057_28417 8.5m
R3900 n46795_47079 n47079_47217 8.5m
R3901 n46795_47079 n46794_47079 8.5m
R3902 n46795_47079 n46795_46794 8.5m
R3903 n46795_47079 n46432_46795 8.5m
R3904 n47079_47217 n46794_47079 8.5m
xmem3905 n13647_13930 n13647_14102 l3905 memristor
R3906 n13647_13930 n13930_13924 8.5m
R3907 n13647_13930 n14102_13930 8.5m
R3908 n7129_7436 n7436_7441 8.5m
R3909 n7129_7436 n7436_8625 8.5m
R3910 n7129_7436 n7129_7441 8.5m
xmem3911 n7436_7441 n7129_7441 l3911 memristor
R3912 n7436_7441 n7436_8625 8.5m
xmem3913 n30177_30867 n30867_30868 l3913 memristor
xmem3914 n30177_30867 n30177_31435 l3914 memristor
R3915 n30177_30867 n30027_30177 8.5m
R3916 n30867_30868 n30868_32229 8.5m
xmem3917 n50339_52067 n52067_52073 l3917 memristor
R3918 n50339_52067 n52067_52117 8.5m
R3919 n50339_52067 n50339_50678 8.5m
xmem3920 n52067_52073 n52067_52117 l3920 memristor
xmem3921 n41625_43333 n43333_44072 l3921 memristor
R3922 n41625_43333 n41200_41625 8.5m
xmem3923 n41625_43333 n41625_41751 l3923 memristor
xmem3924 n6259_6451 n6259_7567 l3924 memristor
R3925 n6259_6451 n6451_6836 8.5m
xmem3926 n6259_7567 n7567_8033 l3926 memristor
R3927 n6259_7567 n7567_6836 8.5m
R3928 n19339_19881 n19338_19339 8.5m
R3929 n29051_29685 n29685_29688 8.5m
xmem3930 n29051_29685 n29051_29458 l3930 memristor
R3931 n29051_29685 n29685_29758 8.5m
xmem3932 n29685_29688 n29458_29688 l3932 memristor
xmem3933 n29685_29688 n29688_30584 l3933 memristor
R3934 n29685_29688 n29685_29758 8.5m
xmem3935 n8925_11816 n11816_12079 l3935 memristor
R3936 n8925_11816 n8925_10105 8.5m
R3937 n8925_11816 n11816_11922 8.5m
R3938 n11816_12079 n11816_11922 8.5m
R3939 n11816_12079 n11936_12079 8.5m
R3940 n11816_12079 n12079_12242 8.5m
xmem3941 n19046_19516 n19046_21001 l3941 memristor
R3942 n19046_19516 n19516_20107 8.5m
xmem3943 n19046_19516 n18690_19046 l3943 memristor
R3944 n19046_21001 n21001_20899 8.5m
R3945 n19046_21001 n21001_21003 8.5m
R3946 n19046_21001 n18690_19046 8.5m
xmem3947 n26380_26999 n26999_27192 l3947 memristor
R3948 n26999_27192 n27192_28455 8.5m
R3949 n29126_29463 n29463_30586 8.5m
xmem3950 n29126_29463 n26629_29126 l3950 memristor
xmem3951 n29126_29463 n29458_29463 l3951 memristor
R3952 n29463_30586 n30586_30584 8.5m
xmem3953 n29463_30586 n29458_29463 l3953 memristor
R3954 n29463_30586 n30586_33054 8.5m
R3955 n33065_33386 n33386_34453 8.5m
R3956 n33065_33386 n33065_33064 8.5m
xmem3957 n33065_33386 n33386_33553 l3957 memristor
xmem3958 n33065_33386 n32394_33065 l3958 memristor
xmem3959 n33386_34453 n33386_33553 l3959 memristor
R3960 n58075_58363 n58140_58363 8.5m
R3961 n58075_58363 n58009_58363 8.5m
xmem3962 n58140_58363 n58009_58363 l3962 memristor
R3963 n52832_52771 n52832_52912 8.5m
xmem3964 n52832_52771 n52295_52771 l3964 memristor
R3965 n52832_52771 n52117_52832 8.5m
xmem3966 n52832_52912 n52912_53475 l3966 memristor
xmem3967 n52832_52912 n52905_52912 l3967 memristor
R3968 n52832_52912 n52117_52832 8.5m
xmem3969 n27099_27349 n27365_27349 l3969 memristor
R3970 n27099_27349 n27349_28589 8.5m
xmem3971 n27365_27349 n27349_28589 l3971 memristor
R3972 n27365_27349 n26994_27365 8.5m
xmem3973 n27365_27349 n27365_28009 l3973 memristor
R3974 n54167_54597 n54597_55019 8.5m
xmem3975 n54167_54597 n53196_54167 l3975 memristor
R3976 n54167_54597 n54219_54597 8.5m
R3977 n54597_55019 n54219_54597 8.5m
R3978 n54597_55019 n54934_55019 8.5m
R3979 n54597_55019 n55019_55846 8.5m
xmem3980 n56955_57620 n57620_57847 l3980 memristor
R3981 n56955_57620 n56863_56955 8.5m
xmem3982 n56955_57620 n57620_57847 l3982 memristor
xmem3983 n56955_57620 n56955_57021 l3983 memristor
xmem3984 n25622_26059 n25265_25622 l3984 memristor
R3985 n25622_26059 n26059_26420 8.5m
xmem3986 n18963_19122 n19122_21660 l3986 memristor
xmem3987 n18963_19122 n18766_18963 l3987 memristor
R3988 n18963_19122 n18767_19122 8.5m
R3989 n18963_19122 n18963_19733 8.5m
R3990 n19122_21660 n18767_19122 8.5m
R3991 n19122_21660 n21660_19891 8.5m
xmem3992 n19122_21660 n21660_22102 l3992 memristor
xmem3993 n13774_13580 n13401_13580 l3993 memristor
R3994 n13774_13580 n13580_13868 8.5m
R3995 n13774_13580 n13774_13965 8.5m
R3996 n13774_13580 n12258_13774 8.5m
R3997 n13401_13580 n13580_13868 8.5m
R3998 n13401_13580 n13401_13868 8.5m
R3999 n13401_13580 n13299_13401 8.5m
R4000 n32844_33339 n32761_32844 8.5m
R4001 n32844_33339 n33339_33437 8.5m
R4002 n16153_16574 n16574_17859 8.5m
R4003 n29810_30646 n30646_31192 8.5m
R4004 n29810_30646 n29515_29810 8.5m
xmem4005 n29810_30646 n30646_30701 l4005 memristor
xmem4006 n29810_30646 n29810_30384 l4006 memristor
xmem4007 n30646_31192 n31192_31606 l4007 memristor
xmem4008 n30646_31192 n30646_30701 l4008 memristor
R4009 n13036_13387 n13387_13764 8.5m
R4010 n13036_13387 n13036_13108 8.5m
xmem4011 n13036_13387 n13387_13293 l4011 memristor
R4012 n13036_13387 n11313_13036 8.5m
R4013 n13387_13764 n13293_13764 8.5m
R4014 n13387_13764 n13387_13293 8.5m
R4015 n7165_8329 n6307_7165 8.5m
R4016 n22924_23303 n23303_24241 8.5m
xmem4017 n22924_23303 n22924_23711 l4017 memristor
xmem4018 n22924_23303 n22725_23303 l4018 memristor
xmem4019 n22924_23303 n22174_22924 l4019 memristor
R4020 n23303_24241 n22725_23303 8.5m
R4021 n23303_24241 n24241_24470 8.5m
xmem4022 n23303_24241 n23711_24241 l4022 memristor
R4023 n5202_5690 n5690_6472 8.5m
R4024 n5202_5690 n5690_6472 8.5m
R4025 n5690_6472 n6472_7344 8.5m
R4026 n24970_25039 n24970_25305 8.5m
xmem4027 n24970_25039 n24219_24970 l4027 memristor
xmem4028 n22806_23171 n22806_22799 l4028 memristor
R4029 n52935_53196 n53196_54167 8.5m
xmem4030 n52935_53196 n53076_53196 l4030 memristor
xmem4031 n588_633 n588_993 l4031 memristor
R4032 n6978_6981 n6981_6987 8.5m
xmem4033 n6978_6981 n6978_8121 l4033 memristor
R4034 n6978_6981 n6351_6978 8.5m
R4035 n6978_6981 n6981_6987 8.5m
R4036 n6981_6987 n6987_7267 8.5m
R4037 n6981_6987 n6987_7267 8.5m
xmem4038 n26704_27715 n27715_27839 l4038 memristor
R4039 n26704_27715 n25916_26704 8.5m
R4040 n27715_27839 n27844_27839 8.5m
xmem4041 n45805_46787 n46152_46787 l4041 memristor
xmem4042 n45805_46787 n46787_47066 l4042 memristor
R4043 n46152_46787 n45799_46152 8.5m
xmem4044 n46152_46787 n46787_47066 l4044 memristor
xmem4045 n28756_29523 n29523_29825 l4045 memristor
xmem4046 n28756_29523 n29523_30080 l4046 memristor
xmem4047 n28756_29523 n28756_29822 l4047 memristor
R4048 n9443_10881 n10881_11054 8.5m
xmem4049 n54297_54474 n54474_54477 l4049 memristor
R4050 n54474_54477 n54052_54477 8.5m
xmem4051 n31733_31815 n31733_32073 l4051 memristor
R4052 n31733_31815 n31815_33115 8.5m
xmem4053 n42400_42387 n42385_42387 l4053 memristor
R4054 n42400_42387 n42400_42569 8.5m
R4055 n42400_42387 n42387_42809 8.5m
R4056 n42385_42387 n42387_42809 8.5m
R4057 n42385_42387 n42058_42385 8.5m
R4058 n42385_42387 n42385_42806 8.5m
xmem4059 n18809_19449 n19449_20305 l4059 memristor
R4060 n18809_19449 n18809_19547 8.5m
R4061 n18809_19449 n19449_19547 8.5m
xmem4062 n19449_20305 n19449_19547 l4062 memristor
R4063 n19449_20305 n20305_20403 8.5m
R4064 n22940_23433 n23429_23433 8.5m
R4065 n22940_23433 n22742_22940 8.5m
R4066 n47318_47002 n47002_47054 8.5m
R4067 n47318_47002 n46623_47002 8.5m
R4068 n47318_47002 n46619_47318 8.5m
xmem4069 n47318_47002 n47318_47759 l4069 memristor
R4070 n47002_47054 n47054_47443 8.5m
xmem4071 n47002_47054 n46623_47002 l4071 memristor
xmem4072 n12054_13076 n13076_13523 l4072 memristor
R4073 n11041_11637 n11041_11922 8.5m
R4074 n9815_9571 n9395_9815 8.5m
R4075 n9815_9571 n9571_11021 8.5m
R4076 n32250_34501 n32250_32913 8.5m
xmem4077 n59153_59366 n59366_59369 l4077 memristor
xmem4078 n54052_54477 n53935_54052 l4078 memristor
xmem4079 n22556_22851 n22851_22855 l4079 memristor
R4080 n22556_22851 n22851_23549 8.5m
R4081 n22556_22851 n22556_23828 8.5m
R4082 n3656_3832 n3832_4675 8.5m
R4083 n3656_3832 n3656_3836 8.5m
R4084 n3656_3832 n3653_3832 8.5m
R4085 n3832_4675 n3653_3832 8.5m
R4086 n13244_13152 n13152_13623 8.5m
xmem4087 n13244_13152 n13244_13623 l4087 memristor
xmem4088 n13244_13152 n12854_13152 l4088 memristor
R4089 n13152_13623 n12854_13152 8.5m
R4090 n13152_13623 n13623_13813 8.5m
xmem4091 n13152_13623 n13244_13623 l4091 memristor
R4092 n59110_59374 n59374_59370 8.5m
R4093 n59110_59374 n59111_59110 8.5m
xmem4094 n59110_59374 n59110_59157 l4094 memristor
R4095 n59374_59370 n59369_59370 8.5m
xmem4096 n59374_59370 n59157_59370 l4096 memristor
R4097 n25473_26212 n24859_26212 8.5m
xmem4098 n25473_26212 n26212_26438 l4098 memristor
R4099 n25473_26212 n21207_25473 8.5m
xmem4100 n27823_28551 n27479_27823 l4100 memristor
xmem4101 n27823_28551 n27313_27823 l4101 memristor
R4102 n22700_22888 n20256_22888 8.5m
R4103 n22700_22888 n22888_24902 8.5m
R4104 n17600_17616 n17616_18596 8.5m
R4105 n17600_17616 n17600_17744 8.5m
R4106 n17600_17616 n17543_17616 8.5m
R4107 n17616_18596 n18596_18598 8.5m
xmem4108 n17616_18596 n17543_17616 l4108 memristor
R4109 n7436_8625 n8625_8465 8.5m
xmem4110 n7436_8625 n8625_11210 l4110 memristor
R4111 n6987_7267 n6981_6987 8.5m
xmem4112 n13039_13490 n13490_13962 l4112 memristor
xmem4113 n13039_13490 n12740_13039 l4113 memristor
R4114 n13039_13490 n13394_13490 8.5m
R4115 n13039_13490 n13039_13670 8.5m
R4116 n13490_13962 n13394_13490 8.5m
R4117 n35506_36041 n36041_36043 8.5m
R4118 n35506_36041 n35348_35506 8.5m
R4119 n35506_36041 n35506_36414 8.5m
R4120 n53954_54369 n54369_54629 8.5m
xmem4121 n53954_54369 n53901_53954 l4121 memristor
R4122 n53954_54369 n54369_54629 8.5m
xmem4123 n53954_54369 n53544_53954 l4123 memristor
R4124 n54369_54629 n54629_54630 8.5m
xmem4125 n7113_7578 n6769_7113 l4125 memristor
R4126 n29174_29170 n29170_30140 8.5m
xmem4127 n29174_29170 n29084_29170 l4127 memristor
xmem4128 n29174_29170 n28306_29174 l4128 memristor
xmem4129 n29170_30140 n29084_29170 l4129 memristor
xmem4130 n29170_30140 n29576_30140 l4130 memristor
R4131 n29170_30140 n30140_30559 8.5m
R4132 n53076_53196 n53196_54167 8.5m
xmem4133 n20354_20576 n20470_20576 l4133 memristor
R4134 n37529_37388 n37145_37388 8.5m
R4135 n8625_8465 n8625_11210 8.5m
xmem4136 n36382_37781 n37781_38341 l4136 memristor
R4137 n25771_25949 n25604_25949 8.5m
xmem4138 n25771_25949 n24903_25771 l4138 memristor
R4139 n25771_25949 n25949_26291 8.5m
xmem4140 n25771_25949 n25766_25771 l4140 memristor
xmem4141 n25604_25949 n25949_26291 l4141 memristor
xmem4142 n25604_25949 n25604_25689 l4142 memristor
R4143 n6451_6836 n7567_6836 8.5m
xmem4144 n6451_6836 n6836_6837 l4144 memristor
xmem4145 n7567_6836 n7567_8033 l4145 memristor
R4146 n7567_6836 n6836_6837 8.5m
R4147 n11816_11922 n11922_13848 8.5m
R4148 n11816_11922 n11041_11922 8.5m
xmem4149 n51556_51563 n51563_52223 l4149 memristor
R4150 n51556_51563 n51563_52229 8.5m
xmem4151 n51556_51563 n51243_51556 l4151 memristor
xmem4152 n51563_52223 n51563_52229 l4152 memristor
xmem4153 n50339_50678 n50678_51702 l4153 memristor
xmem4154 n27672_28256 n27672_28178 l4154 memristor
R4155 n27672_28256 n28256_29188 8.5m
R4156 n27672_28256 n27118_27672 8.5m
R4157 n37781_38341 n38341_38484 8.5m
xmem4158 n55610_55677 n55228_55610 l4158 memristor
R4159 n55610_55677 n55683_55677 8.5m
R4160 n55610_55677 n55677_56147 8.5m
R4161 n14515_14999 n14515_14765 8.5m
xmem4162 n14515_14999 n14999_15003 l4162 memristor
R4163 n14515_14999 n14264_14515 8.5m
xmem4164 n14515_14999 n14999_14765 l4164 memristor
R4165 n14515_14765 n14264_14515 8.5m
xmem4166 n14515_14765 n14999_14765 l4166 memristor
xmem4167 n14515_14765 n14610_14765 l4167 memristor
R4168 n15559_16518 n16518_16901 8.5m
R4169 n15559_16518 n15559_16596 8.5m
xmem4170 n15559_16518 n12159_15559 l4170 memristor
R4171 n15559_16518 n16518_16677 8.5m
xmem4172 n16518_16901 n16518_16677 l4172 memristor
R4173 n16518_16901 n16596_16901 8.5m
R4174 n10521_10620 n10521_10628 8.5m
R4175 n10521_10620 n10620_11066 8.5m
R4176 n17993_18065 n17993_18056 8.5m
R4177 n17993_18065 n17935_18065 8.5m
xmem4178 n17993_18065 n17487_17993 l4178 memristor
R4179 n17993_18065 n18065_18892 8.5m
R4180 n17993_18056 n18056_18265 8.5m
R4181 n17993_18056 n17487_17993 8.5m
xmem4182 n17993_18056 n18050_18056 l4182 memristor
R4183 n16231_16499 n16152_16231 8.5m
R4184 n16231_16499 n16499_17859 8.5m
R4185 n16231_16499 n16499_16497 8.5m
R4186 n18896_19208 n19208_20495 8.5m
R4187 n18896_19208 n19140_19208 8.5m
xmem4188 n18896_19208 n18896_17935 l4188 memristor
xmem4189 n19208_20495 n19140_19208 l4189 memristor
xmem4190 n19208_20495 n20495_20376 l4190 memristor
xmem4191 n53766_54196 n54196_54255 l4191 memristor
R4192 n54196_54255 n54255_54363 8.5m
R4193 n54196_54255 n54255_54623 8.5m
R4194 n33614_33931 n33372_33614 8.5m
R4195 n33614_33931 n33614_33744 8.5m
xmem4196 n8910_9653 n9653_10376 l4196 memristor
xmem4197 n8910_9653 n8912_8910 l4197 memristor
xmem4198 n9653_10376 n9822_10376 l4198 memristor
xmem4199 n9653_10376 n10376_11905 l4199 memristor
R4200 n16460_16277 n16460_16840 8.5m
R4201 n16460_16277 n16047_16460 8.5m
R4202 n16460_16277 n16276_16277 8.5m
R4203 n16460_16840 n16840_18050 8.5m
R4204 n16460_16840 n16047_16460 8.5m
xmem4205 n3304_3625 n3625_3974 l4205 memristor
xmem4206 n3304_3625 n2731_3304 l4206 memristor
xmem4207 n3304_3625 n3304_4279 l4207 memristor
R4208 n39562_39661 n39661_40203 8.5m
R4209 n39562_39661 n39562_40203 8.5m
xmem4210 n39661_40203 n39562_40203 l4210 memristor
xmem4211 n7792_8115 n8115_8436 l4211 memristor
R4212 n7792_8115 n7962_8115 8.5m
xmem4213 n7792_8115 n7792_8116 l4213 memristor
R4214 n8115_8436 n7962_8115 8.5m
xmem4215 n8115_8436 n8116_8436 l4215 memristor
R4216 n8115_8436 n8436_8370 8.5m
xmem4217 n44471_44604 n44471_44531 l4217 memristor
R4218 n55853_56181 n55846_55853 8.5m
R4219 n16721_17171 n17171_17568 8.5m
R4220 n24455_24629 n24454_24455 8.5m
R4221 n16593_16956 n16956_16955 8.5m
R4222 n16593_16956 n16596_16593 8.5m
xmem4223 n16593_16956 n16671_16593 l4223 memristor
R4224 n13965_14543 n14539_14543 8.5m
R4225 n13965_14543 n14543_14781 8.5m
R4226 n13965_14543 n13774_13965 8.5m
xmem4227 n13965_14543 n13965_14214 l4227 memristor
xmem4228 n14539_14543 n14543_14781 l4228 memristor
R4229 n15406_15729 n15729_16108 8.5m
R4230 n15406_15729 n15081_15406 8.5m
xmem4231 n15729_16108 n16108_16269 l4231 memristor
xmem4232 n15729_16108 n16043_16108 l4232 memristor
R4233 n18766_18963 n18963_19733 8.5m
R4234 n18766_18963 n18761_18766 8.5m
xmem4235 n55433_55486 n55486_55826 l4235 memristor
xmem4236 n55433_55486 n55239_55433 l4236 memristor
xmem4237 n41009_42296 n42296_42541 l4237 memristor
R4238 n41009_42296 n42296_42541 8.5m
R4239 n42296_42541 n42541_44679 8.5m
R4240 n24935_25265 n25265_25622 8.5m
xmem4241 n45170_46623 n46623_47002 l4241 memristor
R4242 n45170_46623 n44531_45170 8.5m
xmem4243 n45170_46623 n46623_46619 l4243 memristor
xmem4244 n21060_21074 n20659_21074 l4244 memristor
xmem4245 n7032_7096 n7094_7096 l4245 memristor
xmem4246 n10652_10286 n10652_11853 l4246 memristor
R4247 n10652_10286 n10652_11853 8.5m
xmem4248 n22761_22768 n22761_24412 l4248 memristor
R4249 n22761_22768 n22768_23837 8.5m
R4250 n22761_22768 n22768_22862 8.5m
R4251 n22761_24412 n24412_25745 8.5m
xmem4252 n22761_24412 n24412_24414 l4252 memristor
R4253 n21558_21888 n21888_22788 8.5m
xmem4254 n24077_24438 n24438_24524 l4254 memristor
R4255 n24438_24524 n24524_25689 8.5m
R4256 n24438_24524 n24524_24525 8.5m
R4257 n9384_9727 n9727_9971 8.5m
R4258 n9384_9727 n9727_9564 8.5m
R4259 n9384_9727 n9384_10064 8.5m
R4260 n9727_9971 n9727_9564 8.5m
xmem4261 n9727_9971 n10064_9971 l4261 memristor
R4262 n31841_31930 n31490_31930 8.5m
R4263 n31841_31930 n31841_33609 8.5m
R4264 n31490_31930 n31417_31490 8.5m
R4265 n43270_43984 n43270_43535 8.5m
R4266 n43270_43984 n42994_43270 8.5m
R4267 n43270_43984 n43984_44240 8.5m
xmem4268 n31206_32022 n31206_31426 l4268 memristor
R4269 n26276_26275 n26275_26803 8.5m
R4270 n26275_26803 n26803_26994 8.5m
R4271 n26275_26803 n26716_26803 8.5m
R4272 n21001_21003 n22174_21003 8.5m
R4273 n21001_21003 n21001_20899 8.5m
xmem4274 n21001_21003 n21003_22242 l4274 memristor
xmem4275 n22174_21003 n22174_22924 l4275 memristor
R4276 n22174_21003 n21003_22242 8.5m
R4277 n32538_32773 n32357_32773 8.5m
R4278 n32538_32773 n32085_32538 8.5m
R4279 n40107_40198 n40441_40198 8.5m
xmem4280 n40107_40198 n39485_40107 l4280 memristor
xmem4281 n40107_40198 n40441_40198 l4281 memristor
R4282 n40107_40198 n39485_40107 8.5m
R4283 n36795_37890 n37890_37896 8.5m
xmem4284 n36795_37890 n37890_39513 l4284 memristor
R4285 n3564_3565 n3565_4367 8.5m
R4286 n24384_25816 n25816_26066 8.5m
R4287 n44471_44531 n44528_44531 8.5m
R4288 n44471_44531 n44531_45170 8.5m
R4289 n14276_14350 n14356_14350 8.5m
R4290 n14276_14350 n14350_15154 8.5m
R4291 n14356_14350 n14356_15081 8.5m
xmem4292 n14356_14350 n13951_14356 l4292 memristor
R4293 n14356_14350 n14350_15154 8.5m
R4294 n17600_17744 n17728_17744 8.5m
R4295 n34917_34916 n34916_35344 8.5m
R4296 n33516_34068 n34068_34169 8.5m
xmem4297 n33516_34068 n34164_34068 l4297 memristor
R4298 n34068_34169 n34164_34068 8.5m
R4299 n34068_34169 n34169_36232 8.5m
R4300 n34068_34169 n34169_35161 8.5m
xmem4301 n25604_25689 n24524_25689 l4301 memristor
R4302 n24454_24455 n24455_24629 8.5m
R4303 n24454_24455 n23405_24454 8.5m
xmem4304 n22403_23105 n22102_22403 l4304 memristor
R4305 n9414_10865 n10865_11296 8.5m
xmem4306 n9414_10865 n10865_11296 l4306 memristor
R4307 n9414_10865 n9414_9672 8.5m
R4308 n10865_11296 n11296_12642 8.5m
xmem4309 n15145_15476 n15476_15876 l4309 memristor
R4310 n15145_15476 n14520_15145 8.5m
R4311 n15145_15476 n15794_15476 8.5m
xmem4312 n15145_15476 n15145_15134 l4312 memristor
xmem4313 n15476_15876 n15794_15476 l4313 memristor
R4314 n25636_26087 n25636_26438 8.5m
xmem4315 n25636_26087 n25562_25636 l4315 memristor
xmem4316 n25636_26087 n26087_26444 l4316 memristor
R4317 n25636_26087 n26087_26336 8.5m
R4318 n25636_26438 n26438_26444 8.5m
R4319 n25636_26438 n26212_26438 8.5m
xmem4320 n25636_26438 n25562_25636 l4320 memristor
xmem4321 n40327_43142 n40327_40874 l4321 memristor
xmem4322 n8799_9107 n8587_8799 l4322 memristor
xmem4323 n8799_9107 n9107_9533 l4323 memristor
xmem4324 n8799_9107 n8799_8803 l4324 memristor
R4325 n33065_33064 n32394_33065 8.5m
R4326 n43984_44240 n43479_44240 8.5m
xmem4327 n43984_44240 n44240_46637 l4327 memristor
xmem4328 n33557_33553 n32037_33557 l4328 memristor
R4329 n33557_33553 n33386_33553 8.5m
xmem4330 n56863_57021 n56955_57021 l4330 memristor
R4331 n56863_57021 n56863_56955 8.5m
xmem4332 n17875_18767 n18767_19122 l4332 memristor
xmem4333 n17875_18767 n17728_17875 l4333 memristor
R4334 n9550_10349 n9628_10349 8.5m
R4335 n9550_10349 n8609_9550 8.5m
xmem4336 n23829_24876 n23828_23829 l4336 memristor
R4337 n23829_24876 n23834_24876 8.5m
R4338 n23829_24876 n23834_23829 8.5m
xmem4339 n9571_11021 n11210_11021 l4339 memristor
R4340 n53003_53007 n53003_53649 8.5m
R4341 n53003_53007 n52562_53003 8.5m
R4342 n435_496 n496_994 8.5m
xmem4343 n17867_17980 n16955_17867 l4343 memristor
xmem4344 n17867_17980 n17980_18410 l4344 memristor
R4345 n17867_17980 n17980_18870 8.5m
R4346 n6118_6812 n6545_6812 8.5m
R4347 n6118_6812 n6812_7555 8.5m
R4348 n6118_6812 n6118_6545 8.5m
xmem4349 n6118_6812 n5823_6118 l4349 memristor
R4350 n6545_6812 n6545_7844 8.5m
R4351 n6545_6812 n6812_7555 8.5m
R4352 n6545_6812 n6118_6545 8.5m
xmem4353 n54219_54222 n54219_54597 l4353 memristor
R4354 n54219_54222 n54043_54219 8.5m
R4355 n54219_54222 n54222_54402 8.5m
xmem4356 n54630_54565 n54565_54796 l4356 memristor
R4357 n54630_54565 n54629_54630 8.5m
R4358 n54630_54565 n54630_54796 8.5m
R4359 n54565_54796 n54630_54796 8.5m
xmem4360 n54565_54796 n54796_55228 l4360 memristor
xmem4361 n16461_16472 n16280_16461 l4361 memristor
xmem4362 n40521_40759 n40521_40911 l4362 memristor
xmem4363 n40521_40759 n40759_40908 l4363 memristor
xmem4364 n40521_40759 n40759_40757 l4364 memristor
xmem4365 n40521_40911 n40911_40908 l4365 memristor
R4366 n40521_40911 n40911_41200 8.5m
R4367 n40345_40891 n40796_40891 8.5m
R4368 n40345_40891 n40796_40891 8.5m
xmem4369 n40345_40891 n40345_40563 l4369 memristor
R4370 n40345_40891 n39316_40345 8.5m
xmem4371 n9414_9672 n9672_9835 l4371 memristor
R4372 n33336_33971 n33971_33976 8.5m
R4373 n33336_33971 n33971_34424 8.5m
R4374 n33971_33976 n33971_34424 8.5m
xmem4375 n52301_52449 n52449_52450 l4375 memristor
R4376 n52301_52449 n52449_52645 8.5m
xmem4377 n26671_27311 n27311_27479 l4377 memristor
xmem4378 n36043_37237 n36041_36043 l4378 memristor
R4379 n36043_37237 n37237_37328 8.5m
R4380 n10064_9971 n9384_10064 8.5m
R4381 n38527_38529 n38529_38872 8.5m
xmem4382 n38527_38529 n38153_38527 l4382 memristor
R4383 n38527_38529 n38529_38871 8.5m
R4384 n38527_38529 n38527_38871 8.5m
R4385 n38529_38872 n38529_38871 8.5m
R4386 n38529_38872 n36721_38872 8.5m
R4387 n36656_36743 n36743_37204 8.5m
xmem4388 n36656_36743 n36747_36743 l4388 memristor
R4389 n36743_37204 n36747_36743 8.5m
xmem4390 n36743_37204 n37204_39030 l4390 memristor
R4391 n36682_37138 n35577_36682 8.5m
R4392 n36682_37138 n36682_36927 8.5m
R4393 n40881_40874 n40327_40874 8.5m
R4394 n40881_40874 n40874_41798 8.5m
xmem4395 n40327_40874 n40874_41798 l4395 memristor
xmem4396 n23828_23829 n23834_23829 l4396 memristor
R4397 n23828_23829 n22556_23828 8.5m
R4398 n23828_23829 n23828_23823 8.5m
xmem4399 n53003_53649 n53649_53901 l4399 memristor
R4400 n53003_53649 n52562_53003 8.5m
xmem4401 n53003_53649 n53645_53649 l4401 memristor
R4402 n20223_21310 n21310_21696 8.5m
R4403 n16014_16152 n16152_16231 8.5m
R4404 n21306_21413 n21413_21777 8.5m
R4405 n21306_21413 n21413_21691 8.5m
R4406 n21306_21413 n21210_21306 8.5m
R4407 n21306_21413 n21306_21691 8.5m
R4408 n21413_21777 n21696_21777 8.5m
R4409 n21413_21777 n21413_21691 8.5m
R4410 n21413_21777 n21777_21857 8.5m
R4411 n21945_22012 n22012_22138 8.5m
R4412 n21945_22012 n21811_22012 8.5m
xmem4413 n21945_22012 n21155_21945 l4413 memristor
xmem4414 n21945_22012 n21945_22016 l4414 memristor
xmem4415 n22012_22138 n22138_22285 l4415 memristor
R4416 n22012_22138 n21811_22138 8.5m
R4417 n22012_22138 n21811_22012 8.5m
xmem4418 n9822_10376 n10376_11905 l4418 memristor
R4419 n9822_10376 n9582_9822 8.5m
R4420 n19098_19487 n19401_19487 8.5m
xmem4421 n19098_19487 n18866_19098 l4421 memristor
R4422 n19098_19487 n19098_19401 8.5m
R4423 n19098_19487 n19487_20345 8.5m
R4424 n19401_19487 n19401_20457 8.5m
R4425 n19401_19487 n19098_19401 8.5m
R4426 n19401_19487 n19487_20345 8.5m
R4427 n27998_28242 n28242_29093 8.5m
R4428 n27269_27515 n27269_27723 8.5m
R4429 n18050_18056 n18056_18265 8.5m
R4430 n18050_18056 n16840_18050 8.5m
R4431 n18050_18056 n18050_18265 8.5m
xmem4432 n18056_18265 n18050_18265 l4432 memristor
xmem4433 n25548_26665 n26665_26066 l4433 memristor
R4434 n25548_26665 n26312_26665 8.5m
xmem4435 n40822_40826 n40752_40826 l4435 memristor
R4436 n40822_40826 n39701_40822 8.5m
xmem4437 n40822_40826 n40826_41682 l4437 memristor
R4438 n40822_40826 n39696_40822 8.5m
R4439 n40752_40826 n40826_41682 8.5m
xmem4440 n14999_15003 n14999_14765 l4440 memristor
R4441 n46319_46663 n46663_46794 8.5m
xmem4442 n46319_46663 n45973_46319 l4442 memristor
R4443 n46319_46663 n46319_46432 8.5m
R4444 n33921_34092 n34092_34093 8.5m
R4445 n33921_34092 n32463_33921 8.5m
xmem4446 n34092_34093 n34006_34093 l4446 memristor
xmem4447 n34092_34093 n33921_34092 l4447 memristor
R4448 n27031_27223 n27031_27630 8.5m
xmem4449 n27031_27223 n27228_27223 l4449 memristor
R4450 n27031_27223 n27223_27630 8.5m
R4451 n41623_41751 n41625_41751 8.5m
xmem4452 n41623_41751 n41751_41752 l4452 memristor
R4453 n41623_41751 n41263_41623 8.5m
xmem4454 n16047_16460 n15577_16047 l4454 memristor
xmem4455 n16047_16460 n16047_16203 l4455 memristor
R4456 n52605_53333 n52605_53026 8.5m
xmem4457 n52605_53333 n52605_52963 l4457 memristor
xmem4458 n30076_30157 n29351_30076 l4458 memristor
R4459 n30076_30157 n30076_30577 8.5m
xmem4460 n23046_23895 n23135_23046 l4460 memristor
xmem4461 n41316_42037 n42037_45226 l4461 memristor
R4462 n41316_42037 n42037_42371 8.5m
R4463 n41316_42037 n41316_42371 8.5m
R4464 n42037_45226 n42037_42371 8.5m
R4465 n42037_45226 n45311_45226 8.5m
R4466 n25366_25305 n24970_25305 8.5m
R4467 n33352_34160 n34160_35260 8.5m
xmem4468 n33352_34160 n33352_33346 l4468 memristor
xmem4469 n9591_9835 n9672_9835 l4469 memristor
xmem4470 n9591_9835 n9672_9835 l4470 memristor
xmem4471 n31268_31342 n31541_31342 l4471 memristor
xmem4472 n3662_3918 n3505_3662 l4472 memristor
R4473 n3662_3918 n3657_3662 8.5m
xmem4474 n6069_6320 n6320_7694 l4474 memristor
R4475 n6069_6320 n5112_6069 8.5m
xmem4476 n6069_6320 n6069_6074 l4476 memristor
R4477 n6320_7694 n7694_8167 8.5m
xmem4478 n6320_7694 n7694_6828 l4478 memristor
R4479 n15111_15444 n15444_15683 8.5m
xmem4480 n15111_15444 n15444_15450 l4480 memristor
xmem4481 n44528_44531 n44531_45170 l4481 memristor
xmem4482 n43270_43535 n43535_43812 l4482 memristor
xmem4483 n43270_43535 n42994_43270 l4483 memristor
R4484 n57453_57608 n57608_57887 8.5m
R4485 n57453_57608 n57453_57887 8.5m
xmem4486 n57453_57608 n57551_57453 l4486 memristor
xmem4487 n57608_57887 n57453_57887 l4487 memristor
R4488 n22820_23405 n23405_23499 8.5m
R4489 n22820_23405 n23405_24454 8.5m
xmem4490 n22820_23405 n22820_22421 l4490 memristor
R4491 n23405_23499 n23405_24454 8.5m
R4492 n24859_24663 n24859_26212 8.5m
xmem4493 n42331_42274 n42274_44053 l4493 memristor
R4494 n42331_42274 n41752_42274 8.5m
xmem4495 n20496_20497 n20497_20845 l4495 memristor
R4496 n20496_20497 n19220_20497 8.5m
R4497 n20497_20845 n20845_21194 8.5m
R4498 n20497_20845 n19220_20497 8.5m
xmem4499 n18740_19018 n19018_19245 l4499 memristor
R4500 n18740_19018 n18740_18856 8.5m
xmem4501 n18740_19018 n18305_19018 l4501 memristor
xmem4502 n18740_19018 n18305_18740 l4502 memristor
R4503 n19018_19245 n18856_19245 8.5m
xmem4504 n19018_19245 n18305_19018 l4504 memristor
R4505 n27228_27223 n27228_28619 8.5m
R4506 n27228_27223 n27223_27630 8.5m
xmem4507 n27228_27223 n26312_27228 l4507 memristor
xmem4508 n27228_28619 n26312_27228 l4508 memristor
xmem4509 n36721_38872 n36311_36721 l4509 memristor
R4510 n36425_36423 n36423_36882 8.5m
xmem4511 n36425_36423 n36425_36562 l4511 memristor
R4512 n36425_36423 n35787_36425 8.5m
xmem4513 n36425_36423 n36297_36423 l4513 memristor
R4514 n36423_36882 n36882_37343 8.5m
R4515 n36423_36882 n36297_36423 8.5m
xmem4516 n36423_36882 n36882_36562 l4516 memristor
R4517 n2311_2663 n2663_4279 8.5m
xmem4518 n2311_2663 n2731_2663 l4518 memristor
xmem4519 n46309_46728 n46728_47120 l4519 memristor
R4520 n26212_26438 n26438_26444 8.5m
xmem4521 n26212_26438 n24859_26212 l4521 memristor
xmem4522 n26438_26444 n26087_26444 l4522 memristor
R4523 n19093_19785 n19093_19713 8.5m
R4524 n3473_4120 n4047_4120 8.5m
R4525 n22768_22862 n22768_23837 8.5m
R4526 n9582_10569 n10569_10674 8.5m
xmem4527 n9582_10569 n9582_9822 l4527 memristor
R4528 n10569_10674 n10674_10948 8.5m
R4529 n11019_10760 n11019_11115 8.5m
xmem4530 n52912_53475 n52905_52912 l4530 memristor
R4531 n52912_53475 n53423_53475 8.5m
xmem4532 n49203_49486 n49486_49544 l4532 memristor
xmem4533 n49203_49486 n49486_49605 l4533 memristor
R4534 n49203_49486 n48882_49203 8.5m
R4535 n49486_49544 n49486_49605 8.5m
R4536 n49486_49544 n49544_49605 8.5m
R4537 n49486_49544 n48882_49544 8.5m
R4538 n5324_5019 n4812_5324 8.5m
R4539 n5324_5019 n5324_5394 8.5m
xmem4540 n41798_42079 n40874_41798 l4540 memristor
R4541 n46794_47079 n46795_46794 8.5m
R4542 n46794_47079 n46663_46794 8.5m
R4543 n42750_42806 n42806_43117 8.5m
R4544 n42750_42806 n42385_42806 8.5m
R4545 n42750_42806 n42058_42750 8.5m
R4546 n35577_36682 n36682_36927 8.5m
xmem4547 n28242_29093 n29093_29342 l4547 memristor
R4548 n28242_29093 n29030_29093 8.5m
xmem4549 n37343_37596 n37420_37596 l4549 memristor
R4550 n37343_37596 n36882_37343 8.5m
R4551 n37343_37596 n37596_38060 8.5m
R4552 n37343_37596 n37257_37343 8.5m
R4553 n37420_37596 n36888_37420 8.5m
xmem4554 n37420_37596 n37596_38060 l4554 memristor
R4555 n37420_37596 n37420_37490 8.5m
xmem4556 n34160_35260 n35260_35767 l4556 memristor
xmem4557 n31815_33115 n33115_33346 l4557 memristor
xmem4558 n31815_33115 n31818_33115 l4558 memristor
R4559 n14781_15577 n15577_16047 8.5m
R4560 n14781_15577 n14543_14781 8.5m
R4561 n29051_29458 n29458_29463 8.5m
xmem4562 n29051_29458 n29458_29688 l4562 memristor
R4563 n29458_29463 n29458_29688 8.5m
R4564 n27879_28192 n27883_28192 8.5m
R4565 n27879_28192 n27143_27879 8.5m
R4566 n27879_28192 n28192_28688 8.5m
xmem4567 n27879_28192 n27879_27814 l4567 memristor
xmem4568 n27883_28192 n28192_28688 l4568 memristor
R4569 n27883_28192 n27687_27883 8.5m
xmem4570 n13864_14284 n13299_13864 l4570 memristor
R4571 n38121_38719 n38719_38990 8.5m
R4572 n38121_38719 n38360_38719 8.5m
R4573 n38121_38719 n38121_38500 8.5m
R4574 n38121_38719 n38119_38121 8.5m
R4575 n38719_38990 n38360_38719 8.5m
R4576 n52139_52508 n52139_52251 8.5m
xmem4577 n52139_52508 n52508_52650 l4577 memristor
R4578 n55228_55610 n55055_55228 8.5m
xmem4579 n55228_55610 n54796_55228 l4579 memristor
xmem4580 n54600_54812 n54402_54600 l4580 memristor
R4581 n54600_54812 n54812_54934 8.5m
R4582 n54043_54219 n54219_54597 8.5m
R4583 n54043_54219 n53917_54043 8.5m
R4584 n29607_30375 n30375_30381 8.5m
xmem4585 n29607_30375 n30375_30913 l4585 memristor
R4586 n29607_30375 n29512_29607 8.5m
R4587 n29607_30375 n29592_29607 8.5m
R4588 n30375_30381 n30375_30913 8.5m
R4589 n13039_13670 n12740_13039 8.5m
xmem4590 n27285_27948 n27948_28326 l4590 memristor
xmem4591 n27285_27948 n27805_27948 l4591 memristor
xmem4592 n27285_27948 n27285_27283 l4592 memristor
R4593 n48882_49544 n49544_49605 8.5m
xmem4594 n48882_49544 n48882_49203 l4594 memristor
R4595 n49544_49605 n49486_49605 8.5m
R4596 n49544_49605 n49610_49605 8.5m
xmem4597 n42994_43270 n42874_42994 l4597 memristor
xmem4598 n22542_22742 n22742_23429 l4598 memristor
R4599 n22542_22742 n22742_22940 8.5m
xmem4600 n22542_22742 n22542_22639 l4600 memristor
R4601 n22542_22742 n22120_22542 8.5m
xmem4602 n22742_23429 n23429_23433 l4602 memristor
R4603 n22742_23429 n23429_23520 8.5m
R4604 n22742_23429 n22742_22940 8.5m
R4605 n23682_23857 n23577_23857 8.5m
xmem4606 n23682_23857 n23857_24903 l4606 memristor
R4607 n11317_11313 n11313_13036 8.5m
R4608 n11317_11313 n12491_11317 8.5m
R4609 n11317_11313 n11056_11313 8.5m
R4610 n11313_13036 n13036_13108 8.5m
R4611 n11313_13036 n11056_11313 8.5m
xmem4612 n27085_27844 n27844_28306 l4612 memristor
xmem4613 n27085_27844 n27844_27839 l4613 memristor
xmem4614 n27844_28306 n28306_29174 l4614 memristor
xmem4615 n27844_28306 n28306_29503 l4615 memristor
R4616 n27844_28306 n27844_27839 8.5m
xmem4617 n27479_27823 n27313_27823 l4617 memristor
R4618 n27479_27823 n27311_27479 8.5m
xmem4619 n27313_27823 n27564_27313 l4619 memristor
R4620 n16970_17039 n16970_17133 8.5m
xmem4621 n16970_17039 n16269_16970 l4621 memristor
R4622 n16970_17039 n17038_17039 8.5m
R4623 n47251_47382 n47382_47576 8.5m
R4624 n47251_47382 n47382_47506 8.5m
R4625 n27687_26656 n26661_26656 8.5m
R4626 n27687_26656 n27687_27883 8.5m
xmem4627 n32923_33310 n33310_36164 l4627 memristor
R4628 n32923_33310 n33310_36164 8.5m
R4629 n39768_39836 n39497_39836 8.5m
R4630 n39768_39836 n39841_39836 8.5m
xmem4631 n39768_39836 n39316_39768 l4631 memristor
R4632 n39768_39836 n39422_39768 8.5m
R4633 n39497_39836 n39497_39841 8.5m
xmem4634 n39497_39836 n39325_39497 l4634 memristor
R4635 n39497_39836 n39841_39836 8.5m
R4636 n52348_52346 n52346_52613 8.5m
R4637 n18050_18265 n16840_18050 8.5m
xmem4638 n29030_29592 n29592_29607 l4638 memristor
R4639 n29030_29592 n29592_30320 8.5m
R4640 n29030_29592 n29030_29093 8.5m
xmem4641 n29030_29592 n27929_29030 l4641 memristor
xmem4642 n29592_29607 n29592_30320 l4642 memristor
xmem4643 n29592_29607 n29512_29607 l4643 memristor
R4644 n46637_47632 n47632_49138 8.5m
R4645 n46637_47632 n46484_46637 8.5m
R4646 n46637_47632 n47632_47639 8.5m
xmem4647 n46637_47632 n44240_46637 l4647 memristor
R4648 n47632_49138 n48955_49138 8.5m
xmem4649 n47632_49138 n47632_47639 l4649 memristor
xmem4650 n35928_36084 n36084_36380 l4650 memristor
xmem4651 n16494_16491 n16491_17180 l4651 memristor
R4652 n16494_16491 n16418_16491 8.5m
R4653 n41752_42274 n42274_44053 8.5m
R4654 n41752_42274 n41751_41752 8.5m
R4655 n42274_44053 n44053_44052 8.5m
R4656 n50001_49838 n49177_49838 8.5m
R4657 n50001_49838 n50001_50435 8.5m
xmem4658 n28192_28688 n28688_29385 l4658 memristor
xmem4659 n28688_29385 n29289_29385 l4659 memristor
xmem4660 n57861_58344 n58344_58338 l4660 memristor
R4661 n58344_58338 n57861_58344 8.5m
R4662 n19255_19182 n19255_19405 8.5m
R4663 n19255_19182 n18870_19182 8.5m
R4664 n19255_19182 n18866_19255 8.5m
R4665 n36621_37691 n37691_37806 8.5m
R4666 n36621_37691 n36476_36621 8.5m
xmem4667 n36621_37691 n36476_36621 l4667 memristor
R4668 n30586_30584 n30586_33054 8.5m
R4669 n30586_30584 n29688_30584 8.5m
R4670 n30586_30584 n29758_30584 8.5m
R4671 n22875_22965 n22965_23458 8.5m
xmem4672 n50413_50501 n50413_50502 l4672 memristor
R4673 n50413_50501 n50501_50598 8.5m
xmem4674 n50413_50501 n50349_50501 l4674 memristor
xmem4675 n50413_50501 n50349_50413 l4675 memristor
R4676 n50413_50502 n50502_50598 8.5m
xmem4677 n50413_50502 n50502_50598 l4677 memristor
xmem4678 n50413_50502 n50349_50413 l4678 memristor
xmem4679 n16491_17180 n16418_16491 l4679 memristor
xmem4680 n16491_17180 n17180_17182 l4680 memristor
R4681 n16491_17180 n17180_17182 8.5m
R4682 n25887_27143 n27143_27879 8.5m
R4683 n25887_27143 n25794_25887 8.5m
xmem4684 n32966_33685 n33685_33860 l4684 memristor
R4685 n32966_33685 n33685_34232 8.5m
R4686 n32966_33685 n32966_33267 8.5m
R4687 n8167_8508 n8508_8509 8.5m
R4688 n8167_8508 n8508_8509 8.5m
R4689 n8167_8508 n7694_8167 8.5m
R4690 n53917_53514 n53917_54043 8.5m
xmem4691 n53917_53514 n53340_53917 l4691 memristor
R4692 n53917_53514 n53275_53514 8.5m
xmem4693 n53917_54043 n53340_53917 l4693 memristor
xmem4694 n35693_36052 n36052_36297 l4694 memristor
xmem4695 n36052_36297 n36297_37257 l4695 memristor
R4696 n36052_36297 n36297_36423 8.5m
R4697 n10187_10327 n10327_12491 8.5m
xmem4698 n10327_12491 n12491_13394 l4698 memristor
R4699 n10327_12491 n12491_11317 8.5m
R4700 n32233_32903 n32657_32903 8.5m
R4701 n32233_32903 n32232_32233 8.5m
xmem4702 n32657_32903 n32233_32903 l4702 memristor
R4703 n36425_36562 n35787_36425 8.5m
R4704 n36425_36562 n36882_36562 8.5m
xmem4705 n20925_21403 n21403_21509 l4705 memristor
R4706 n20925_21403 n21395_21403 8.5m
R4707 n21403_21509 n21395_21403 8.5m
R4708 n21696_21777 n21777_21857 8.5m
xmem4709 n21696_21777 n21310_21696 l4709 memristor
xmem4710 n29523_30080 n29523_29825 l4710 memristor
R4711 n13299_13401 n13401_13868 8.5m
xmem4712 n13299_13401 n13299_13864 l4712 memristor
R4713 n13299_13401 n12746_13299 8.5m
R4714 n13401_13868 n13580_13868 8.5m
R4715 n7884_8609 n8609_9550 8.5m
R4716 n47632_47639 n47639_49435 8.5m
R4717 n47632_47639 n47259_47639 8.5m
R4718 n47639_49435 n47259_47639 8.5m
xmem4719 n47639_49435 n49435_49769 l4719 memristor
R4720 n47120_47124 n47124_47649 8.5m
R4721 n47120_47124 n47120_47649 8.5m
R4722 n47120_47124 n47066_47124 8.5m
R4723 n47120_47124 n46728_47120 8.5m
R4724 n47124_47649 n47066_47124 8.5m
R4725 n47124_47649 n47120_47649 8.5m
R4726 n47124_47649 n47527_47649 8.5m
xmem4727 n13720_14244 n13720_14316 l4727 memristor
R4728 n13720_14244 n12927_13720 8.5m
R4729 n13720_14244 n14079_14244 8.5m
R4730 n30369_30492 n30369_30630 8.5m
xmem4731 n30369_30492 n30320_30492 l4731 memristor
R4732 n30369_30492 n29342_30369 8.5m
R4733 n18761_19036 n19036_19732 8.5m
xmem4734 n18761_19036 n18175_18761 l4734 memristor
xmem4735 n18761_19036 n18761_18766 l4735 memristor
R4736 n35787_36425 n35695_35787 8.5m
R4737 n3263_3505 n3505_3662 8.5m
R4738 n3263_3505 n3508_3505 8.5m
R4739 n3505_3662 n3508_3505 8.5m
xmem4740 n3505_3662 n3657_3662 l4740 memristor
R4741 n39485_40107 n39297_39485 8.5m
R4742 n30868_32229 n32229_32891 8.5m
xmem4743 n30868_32229 n32229_32640 l4743 memristor
R4744 n32229_32891 n32229_32640 8.5m
R4745 n32229_32891 n32891_32888 8.5m
xmem4746 n42058_42385 n42058_42750 l4746 memristor
R4747 n42058_42385 n40771_42058 8.5m
R4748 n42058_42385 n42385_42806 8.5m
R4749 n42058_42750 n40771_42058 8.5m
xmem4750 n23429_23433 n23429_23520 l4750 memristor
xmem4751 n36084_36380 n36380_36453 l4751 memristor
xmem4752 n36084_36380 n36380_36453 l4752 memristor
R4753 n45482_45973 n45973_46432 8.5m
xmem4754 n45482_45973 n45973_46319 l4754 memristor
R4755 n45482_45973 n45271_45482 8.5m
xmem4756 n30027_30177 n30177_31435 l4756 memristor
xmem4757 n55846_55853 n55846_56937 l4757 memristor
R4758 n55846_55853 n55019_55846 8.5m
R4759 n55846_56937 n55019_55846 8.5m
xmem4760 n16423_16497 n16499_16497 l4760 memristor
R4761 n16423_16497 n16658_16497 8.5m
R4762 n31119_31200 n30995_31200 8.5m
R4763 n31119_31200 n31119_31130 8.5m
xmem4764 n26010_26468 n25168_26010 l4764 memristor
R4765 n26010_26468 n26010_26249 8.5m
R4766 n9161_9389 n8899_9161 8.5m
R4767 n9161_9389 n9389_9564 8.5m
xmem4768 n52605_53026 n52605_52963 l4768 memristor
R4769 n52605_53026 n53026_53028 8.5m
xmem4770 n52605_53026 n53026_53340 l4770 memristor
R4771 n37490_37709 n37420_37490 8.5m
R4772 n37490_37709 n36957_37490 8.5m
R4773 n50210_50601 n50210_50309 8.5m
xmem4774 n50210_50601 n50108_50210 l4774 memristor
xmem4775 n32085_32200 n32085_32538 l4775 memristor
R4776 n30366_30762 n30262_30366 8.5m
xmem4777 n30366_30762 n30366_31094 l4777 memristor
xmem4778 n14520_15145 n15145_15134 l4778 memristor
xmem4779 n15145_15134 n15133_15134 l4779 memristor
xmem4780 n57411_57638 n57638_58044 l4780 memristor
R4781 n57411_57638 n55827_57411 8.5m
xmem4782 n57638_58044 n57411_57638 l4782 memristor
R4783 n57638_58044 n58160_58044 8.5m
R4784 n57638_58044 n58160_58044 8.5m
R4785 n15133_15134 n15133_15709 8.5m
R4786 n47382_47576 n47576_47759 8.5m
R4787 n47382_47576 n47443_47576 8.5m
R4788 n47382_47576 n47382_47506 8.5m
R4789 n47576_47759 n47318_47759 8.5m
R4790 n47576_47759 n47763_47759 8.5m
xmem4791 n47576_47759 n47443_47576 l4791 memristor
xmem4792 n12258_13774 n13774_13965 l4792 memristor
R4793 n12258_13774 n10727_12258 8.5m
xmem4794 n13774_13965 n13965_14214 l4794 memristor
R4795 n25816_26066 n26665_26066 8.5m
R4796 n57411_57638 n55827_57411 8.5m
xmem4797 n22174_22924 n22924_23711 l4797 memristor
R4798 n13076_13523 n13523_14074 8.5m
xmem4799 n9461_9456 n9456_10026 l4799 memristor
xmem4800 n10948_13905 n13905_14597 l4800 memristor
xmem4801 n10948_13905 n10945_10948 l4801 memristor
xmem4802 n10948_13905 n13905_14594 l4802 memristor
R4803 n10948_13905 n10674_10948 8.5m
xmem4804 n13905_14597 n13905_14594 l4804 memristor
xmem4805 n39128_39316 n39316_40345 l4805 memristor
xmem4806 n39128_39316 n39316_39768 l4806 memristor
R4807 n20845_21194 n21395_21194 8.5m
R4808 n3146_3790 n3790_4192 8.5m
R4809 n3146_3790 n2933_3146 8.5m
xmem4810 n3146_3790 n2933_3146 l4810 memristor
R4811 n3146_3790 n3790_4192 8.5m
xmem4812 n43709_43782 n43709_43843 l4812 memristor
R4813 n43709_43782 n43373_43709 8.5m
R4814 n43709_43843 n43777_43843 8.5m
xmem4815 n43709_43843 n43373_43709 l4815 memristor
R4816 n49996_50176 n50176_50715 8.5m
xmem4817 n49996_50176 n49996_50175 l4817 memristor
R4818 n49996_50176 n49913_49996 8.5m
xmem4819 n49996_50176 n50175_50176 l4819 memristor
R4820 n50176_50715 n50175_50176 8.5m
R4821 n50176_50715 n50715_50665 8.5m
R4822 n50176_50715 n50715_50905 8.5m
xmem4823 n31344_31481 n31481_31606 l4823 memristor
R4824 n31481_31606 n31606_31754 8.5m
R4825 n31481_31606 n31192_31606 8.5m
R4826 n23135_23046 n23135_23631 8.5m
xmem4827 n55683_56063 n55826_56063 l4827 memristor
xmem4828 n55683_56063 n55683_55677 l4828 memristor
R4829 n55683_56063 n56147_56063 8.5m
R4830 n55826_56063 n55826_55827 8.5m
xmem4831 n55826_56063 n56147_56063 l4831 memristor
R4832 n55826_56063 n55486_55826 8.5m
R4833 n8184_8524 n8524_8974 8.5m
xmem4834 n8184_8524 n8057_8184 l4834 memristor
xmem4835 n8184_8524 n8524_8527 l4835 memristor
R4836 n8524_8974 n8524_8527 8.5m
xmem4837 n39003_39787 n39437_39787 l4837 memristor
R4838 n39003_39787 n39933_39787 8.5m
xmem4839 n39437_39787 n39933_39787 l4839 memristor
xmem4840 n27349_28589 n28589_28591 l4840 memristor
R4841 n38743_38739 n38739_39933 8.5m
R4842 n38743_38739 n38054_38743 8.5m
xmem4843 n15559_16596 n16596_16901 l4843 memristor
xmem4844 n15559_16596 n12159_15559 l4844 memristor
xmem4845 n15559_16596 n16596_16593 l4845 memristor
xmem4846 n16596_16901 n16596_16593 l4846 memristor
R4847 n1035_1346 n1350_1346 8.5m
xmem4848 n59366_59369 n59369_59370 l4848 memristor
xmem4849 n40759_40757 n40759_40908 l4849 memristor
xmem4850 n9766_10105 n10105_10323 l4850 memristor
R4851 n9766_10105 n8925_10105 8.5m
R4852 n9766_10105 n9766_10323 8.5m
xmem4853 n10105_10323 n8925_10105 l4853 memristor
R4854 n10105_10323 n9766_10323 8.5m
R4855 n27143_27879 n27879_27814 8.5m
xmem4856 n38485_40068 n38485_38484 l4856 memristor
xmem4857 n38485_40068 n40068_39963 l4857 memristor
xmem4858 n33685_33860 n33860_34236 l4858 memristor
xmem4859 n33685_33860 n33685_34232 l4859 memristor
R4860 n56573_57069 n56573_56578 8.5m
xmem4861 n29351_30076 n30076_30577 l4861 memristor
xmem4862 n35348_35506 n35506_36414 l4862 memristor
R4863 n12485_13108 n13108_13567 8.5m
R4864 n12485_13108 n13036_13108 8.5m
R4865 n13108_13567 n13036_13108 8.5m
xmem4866 n50665_50906 n50906_50905 l4866 memristor
R4867 n50665_50906 n50906_51243 8.5m
xmem4868 n50665_50906 n50715_50665 l4868 memristor
R4869 n50906_50905 n50715_50905 8.5m
xmem4870 n50906_50905 n50906_51243 l4870 memristor
R4871 n37700_37896 n37890_37896 8.5m
R4872 n37700_37896 n37896_38052 8.5m
xmem4873 n37700_37896 n37700_37897 l4873 memristor
R4874 n7555_8338 n6812_7555 8.5m
R4875 n7555_8338 n8338_8345 8.5m
xmem4876 n26994_27365 n26803_26994 l4876 memristor
xmem4877 n26994_27365 n27365_28009 l4877 memristor
R4878 n52905_52912 n52905_53248 8.5m
xmem4879 n50108_50309 n50210_50309 l4879 memristor
xmem4880 n50108_50309 n50108_50210 l4880 memristor
xmem4881 n50108_50309 n49820_50108 l4881 memristor
R4882 n50501_50598 n50349_50501 8.5m
R4883 n50501_50598 n50502_50598 8.5m
xmem4884 n50501_50598 n50502_50598 l4884 memristor
R4885 n36888_37420 n37420_37490 8.5m
xmem4886 n3565_4367 n4367_5104 l4886 memristor
xmem4887 n4367_5104 n5104_5107 l4887 memristor
xmem4888 n8804_8940 n8940_9858 l4888 memristor
R4889 n8804_8940 n8804_8803 8.5m
R4890 n8804_8940 n9034_8940 8.5m
R4891 n8940_9858 n9034_8940 8.5m
xmem4892 n8940_9858 n9858_9930 l4892 memristor
R4893 n11922_13848 n13848_14193 8.5m
xmem4894 n11922_13848 n13848_13756 l4894 memristor
R4895 n11922_13848 n11041_11922 8.5m
xmem4896 n7344_7887 n8057_7887 l4896 memristor
xmem4897 n7344_7887 n6472_7344 l4897 memristor
xmem4898 n7344_7887 n7344_8057 l4898 memristor
xmem4899 n8057_7887 n7344_8057 l4899 memristor
R4900 n8057_7887 n8057_8184 8.5m
xmem4901 n52533_52736 n52533_53279 l4901 memristor
R4902 n52533_52736 n52613_52736 8.5m
xmem4903 n52533_52736 n52736_53275 l4903 memristor
R4904 n38198_39297 n39297_39485 8.5m
xmem4905 n36747_36743 n36747_37205 l4905 memristor
xmem4906 n19516_20107 n20107_19891 l4906 memristor
R4907 n19516_20107 n20107_20109 8.5m
R4908 n23422_23222 n22059_23422 8.5m
xmem4909 n23422_23222 n23422_24111 l4909 memristor
R4910 n21155_21945 n21945_22016 8.5m
xmem4911 n21155_21945 n21155_21246 l4911 memristor
R4912 n16499_17859 n16499_16497 8.5m
R4913 n16499_17859 n16574_17859 8.5m
R4914 n28756_29822 n29822_29825 8.5m
R4915 n29822_29825 n29523_29825 8.5m
R4916 n13271_13266 n12870_13266 8.5m
xmem4917 n25588_26016 n26016_26258 l4917 memristor
R4918 n25588_26016 n26016_26019 8.5m
R4919 n26016_26258 n26016_26019 8.5m
xmem4920 n54630_54796 n54796_55228 l4920 memristor
xmem4921 n54630_54796 n54629_54630 l4921 memristor
R4922 n54796_55228 n55055_55228 8.5m
R4923 n35324_36927 n36682_36927 8.5m
R4924 n24241_24470 n23711_24241 8.5m
R4925 n13848_14193 n13756_14193 8.5m
R4926 n13848_14193 n13848_13756 8.5m
xmem4927 n13848_14193 n14193_14437 l4927 memristor
R4928 n13756_14193 n14193_14437 8.5m
R4929 n13756_14193 n13757_13756 8.5m
R4930 n13756_14193 n13848_13756 8.5m
xmem4931 n38153_38527 n37424_38153 l4931 memristor
R4932 n38153_38527 n38527_38871 8.5m
xmem4933 n59369_59370 n59157_59370 l4933 memristor
xmem4934 n50349_50501 n49811_50349 l4934 memristor
xmem4935 n50349_50501 n50349_50413 l4935 memristor
R4936 n13647_14102 n14102_13930 8.5m
R4937 n13647_14102 n14102_14604 8.5m
R4938 n14102_13930 n13930_13924 8.5m
R4939 n14102_13930 n14102_14604 8.5m
R4940 n13450_13730 n13159_13450 8.5m
R4941 n20470_20577 n19802_20470 8.5m
xmem4942 n20470_20577 n20470_20576 l4942 memristor
R4943 n24528_24986 n23691_24528 8.5m
R4944 n24528_24986 n24528_24730 8.5m
xmem4945 n14102_14604 n14604_15225 l4945 memristor
R4946 n14102_14604 n14604_14606 8.5m
xmem4947 n14604_15225 n15225_15787 l4947 memristor
xmem4948 n14604_15225 n14604_14606 l4948 memristor
R4949 n14604_15225 n14992_15225 8.5m
R4950 n45069_45008 n45069_45329 8.5m
xmem4951 n45069_45329 n45069_45008 l4951 memristor
R4952 n45069_45329 n45329_46148 8.5m
xmem4953 n24090_24299 n24090_24084 l4953 memristor
xmem4954 n24090_24299 n23297_24090 l4954 memristor
R4955 n24090_24299 n24299_24448 8.5m
xmem4956 n30369_30630 n29342_30369 l4956 memristor
R4957 n363_606 n606_1614 8.5m
xmem4958 n363_606 n234_363 l4958 memristor
xmem4959 n363_606 n606_1614 l4959 memristor
xmem4960 n363_606 n234_363 l4960 memristor
R4961 n39841_39836 n39497_39841 8.5m
R4962 n994_993 n993_1350 8.5m
R4963 n994_993 n496_994 8.5m
R4964 n994_993 n588_993 8.5m
R4965 n993_1350 n1350_1346 8.5m
xmem4966 n993_1350 n588_993 l4966 memristor
R4967 n53544_53599 n53544_53954 8.5m
R4968 n53544_53599 n52924_53544 8.5m
R4969 n53544_53599 n53599_53901 8.5m
xmem4970 n53544_53954 n52924_53544 l4970 memristor
R4971 n53544_53954 n53901_53954 8.5m
xmem4972 n55183_55234 n55183_55236 l4972 memristor
R4973 n39933_39787 n39933_39932 8.5m
R4974 n39933_39787 n38739_39933 8.5m
xmem4975 n39933_39932 n38739_39933 l4975 memristor
R4976 n26653_26527 n26653_27386 8.5m
xmem4977 n49616_49811 n49811_50349 l4977 memristor
R4978 n49616_49811 n49548_49616 8.5m
xmem4979 n10865_11296 n11296_12642 l4979 memristor
R4980 n38485_38484 n38341_38484 8.5m
R4981 n14485_14736 n14736_15275 8.5m
R4982 n14485_14736 n14736_14960 8.5m
R4983 n14736_15275 n14736_14960 8.5m
xmem4984 n14736_15275 n15275_14960 l4984 memristor
R4985 n14736_15275 n13992_15275 8.5m
R4986 n29868_30262 n30262_30366 8.5m
xmem4987 n29868_30262 n29806_29868 l4987 memristor
R4988 n44835_45271 n45271_45482 8.5m
R4989 n46319_46432 n46432_46795 8.5m
xmem4990 n46319_46432 n45973_46432 l4990 memristor
R4991 n46319_46432 n45973_46319 8.5m
xmem4992 n46432_46795 n46795_46794 l4992 memristor
R4993 n46432_46795 n45973_46432 8.5m
R4994 n42806_43117 n43117_43479 8.5m
R4995 n42806_43117 n42385_42806 8.5m
R4996 n14610_14512 n14610_14765 8.5m
xmem4997 n14610_14512 n14264_14610 l4997 memristor
R4998 n17819_18516 n17133_17819 8.5m
R4999 n13293_13389 n13293_13764 8.5m
xmem5000 n13293_13389 n13389_13951 l5000 memristor
R5001 n13293_13389 n13387_13293 8.5m
R5002 n13293_13764 n13387_13293 8.5m
R5003 n27792_27930 n27930_28962 8.5m
xmem5004 n27792_27930 n27930_27929 l5004 memristor
R5005 n27930_28962 n27930_27929 8.5m
xmem5006 n40759_40908 n40908_41258 l5006 memristor
R5007 n40759_40908 n40911_40908 8.5m
R5008 n42569_43541 n42465_42569 8.5m
R5009 n42569_43541 n42400_42569 8.5m
R5010 n55486_55826 n55826_55827 8.5m
xmem5011 n16589_16580 n16953_16580 l5011 memristor
R5012 n16589_16580 n16097_16580 8.5m
R5013 n18373_20158 n20158_20237 8.5m
R5014 n18373_20158 n20158_20425 8.5m
R5015 n20158_20237 n20158_20425 8.5m
R5016 n48035_48923 n48923_48993 8.5m
xmem5017 n48035_48923 n48708_48923 l5017 memristor
R5018 n48923_48993 n48993_49913 8.5m
R5019 n48923_48993 n48708_48923 8.5m
xmem5020 n48923_48993 n49505_48993 l5020 memristor
R5021 n11936_12167 n11936_12079 8.5m
xmem5022 n11936_12167 n11461_12167 l5022 memristor
xmem5023 n11936_12167 n11461_11936 l5023 memristor
xmem5024 n11936_12079 n11461_11936 l5024 memristor
R5025 n11936_12079 n12079_12242 8.5m
xmem5026 n18221_18846 n15683_18221 l5026 memristor
R5027 n18221_18846 n18846_19571 8.5m
R5028 n28306_29503 n29503_29587 8.5m
xmem5029 n28306_29503 n28306_29174 l5029 memristor
R5030 n36414_37079 n35506_36414 8.5m
R5031 n11461_11936 n11461_12167 8.5m
R5032 n11461_11936 n11150_11461 8.5m
xmem5033 n11461_12167 n11150_11461 l5033 memristor
xmem5034 n37330_39513 n37890_39513 l5034 memristor
R5035 n33372_33614 n33259_33372 8.5m
xmem5036 n33372_33614 n33614_33744 l5036 memristor
R5037 n11651_12746 n12746_13299 8.5m
R5038 n11651_12746 n11652_11651 8.5m
xmem5039 n16047_16203 n15577_16047 l5039 memristor
xmem5040 n8524_8527 n8527_8537 l5040 memristor
R5041 n8524_8527 n8527_9628 8.5m
R5042 n8527_8537 n8527_9628 8.5m
R5043 n16956_16955 n16671_16955 8.5m
R5044 n16956_16955 n16955_17867 8.5m
R5045 n4399_4867 n4867_8063 8.5m
R5046 n4399_4867 n3397_4399 8.5m
xmem5047 n4399_4867 n4867_6156 l5047 memristor
R5048 n4867_8063 n4867_6156 8.5m
R5049 n4867_8063 n8063_8619 8.5m
R5050 n28195_28284 n28284_29289 8.5m
xmem5051 n28195_28284 n27630_28195 l5051 memristor
R5052 n28195_28284 n28280_28284 8.5m
xmem5053 n28284_29289 n29289_29385 l5053 memristor
R5054 n28284_29289 n28280_28284 8.5m
xmem5055 n37890_39513 n37890_37896 l5055 memristor
R5056 n21983_26312 n26312_26665 8.5m
R5057 n21983_26312 n21666_21983 8.5m
R5058 n21983_26312 n26312_27228 8.5m
R5059 n26312_26665 n26665_26066 8.5m
xmem5060 n26312_26665 n26312_27228 l5060 memristor
xmem5061 n18963_19733 n19733_21577 l5061 memristor
R5062 n25306_25589 n25589_26125 8.5m
xmem5063 n25306_25589 n25589_26019 l5063 memristor
R5064 n23711_24241 n22924_23711 8.5m
R5065 n6219_6478 n6219_6284 8.5m
xmem5066 n6219_6478 n6478_7427 l5066 memristor
R5067 n6219_6478 n6156_6219 8.5m
xmem5068 n6219_6478 n6478_6284 l5068 memristor
xmem5069 n6219_6284 n6478_6284 l5069 memristor
R5070 n6219_6284 n6156_6219 8.5m
xmem5071 n6219_6284 n6284_7427 l5071 memristor
R5072 n22138_22285 n21811_22138 8.5m
xmem5073 n13244_13623 n13623_13813 l5073 memristor
xmem5074 n21577_21270 n21577_21745 l5074 memristor
R5075 n21577_21270 n19733_21577 8.5m
R5076 n21577_21745 n19733_21577 8.5m
xmem5077 n21577_21745 n21745_21747 l5077 memristor
R5078 n21577_21745 n21745_22508 8.5m
xmem5079 n38529_38871 n38527_38871 l5079 memristor
xmem5080 n24593_25310 n23849_25310 l5080 memristor
R5081 n24593_25310 n24593_23920 8.5m
xmem5082 n24593_25310 n25310_26716 l5082 memristor
R5083 n27285_27283 n27283_27744 8.5m
xmem5084 n14119_14194 n14194_14437 l5084 memristor
xmem5085 n14119_14194 n12242_14119 l5085 memristor
xmem5086 n29592_30320 n30320_31184 l5086 memristor
R5087 n29592_30320 n30320_30492 8.5m
xmem5088 n30320_31184 n31184_31189 l5088 memristor
R5089 n30320_31184 n30320_30492 8.5m
R5090 n30320_31184 n31184_31677 8.5m
xmem5091 n3508_3505 n3508_4924 l5091 memristor
R5092 n3508_4924 n4924_5263 8.5m
R5093 n50108_50210 n50210_50309 8.5m
R5094 n50108_50210 n49820_50108 8.5m
R5095 n8587_8799 n8799_8803 8.5m
R5096 n4596_6307 n5543_6307 8.5m
xmem5097 n4596_6307 n6307_7165 l5097 memristor
xmem5098 n4596_6307 n4596_4795 l5098 memristor
xmem5099 n4596_6307 n4803_4596 l5099 memristor
R5100 n5543_6307 n6307_7165 8.5m
R5101 n40533_40771 n40771_42058 8.5m
xmem5102 n22245_22725 n22421_22725 l5102 memristor
R5103 n22245_22725 n22725_23303 8.5m
xmem5104 n22421_22725 n22725_23303 l5104 memristor
xmem5105 n22421_22725 n22820_22421 l5105 memristor
R5106 n49486_49605 n49610_49605 8.5m
xmem5107 n16955_17867 n16671_16955 l5107 memristor
R5108 n15709_15789 n15789_17329 8.5m
R5109 n15709_15789 n15133_15709 8.5m
xmem5110 n15709_15789 n15709_16953 l5110 memristor
xmem5111 n15709_15789 n15787_15789 l5111 memristor
R5112 n15789_17329 n15787_15789 8.5m
R5113 n15789_17329 n17329_17107 8.5m
R5114 n15789_17329 n17329_17794 8.5m
R5115 n21445_21811 n21811_22012 8.5m
xmem5116 n21445_21811 n21811_22138 l5116 memristor
xmem5117 n12746_13299 n13299_13864 l5117 memristor
xmem5118 n16953_16580 n16953_17107 l5118 memristor
xmem5119 n16953_16580 n16097_16580 l5119 memristor
R5120 n16953_16580 n15709_16953 8.5m
R5121 n16953_17107 n15709_16953 8.5m
R5122 n16953_17107 n17329_17107 8.5m
R5123 n37700_37897 n37897_38052 8.5m
xmem5124 n44052_44703 n44052_45311 l5124 memristor
R5125 n44052_44703 n44053_44052 8.5m
R5126 n44052_44703 n44703_44655 8.5m
xmem5127 n44052_45311 n45311_45226 l5127 memristor
xmem5128 n44052_45311 n45311_45379 l5128 memristor
R5129 n44052_45311 n44053_44052 8.5m
R5130 n36297_37257 n36297_36423 8.5m
R5131 n36297_37257 n37257_37343 8.5m
xmem5132 n4163_5265 n4926_5265 l5132 memristor
R5133 n4163_5265 n4163_10338 8.5m
R5134 n31606_31754 n31750_31754 8.5m
xmem5135 n31606_31754 n31192_31606 l5135 memristor
R5136 n39497_39841 n39325_39497 8.5m
R5137 n19239_19571 n19571_20078 8.5m
R5138 n19239_19571 n18846_19571 8.5m
R5139 n34006_34093 n33259_34006 8.5m
R5140 n36957_37424 n37424_38153 8.5m
R5141 n36957_37424 n36428_36957 8.5m
xmem5142 n36957_37424 n36957_37490 l5142 memristor
R5143 n56566_56506 n55144_56506 8.5m
xmem5144 n56566_56506 n54555_56506 l5144 memristor
xmem5145 n24299_24448 n24448_24991 l5145 memristor
xmem5146 n17478_17728 n17215_17478 l5146 memristor
xmem5147 n17478_17728 n17728_17744 l5147 memristor
xmem5148 n17478_17728 n17728_17875 l5148 memristor
R5149 n12491_11317 n12491_13394 8.5m
xmem5150 n52449_52450 n52450_52645 l5150 memristor
R5151 n52449_52450 n52450_52645 8.5m
R5152 n52449_52450 n52449_52645 8.5m
R5153 n54255_54363 n54255_54623 8.5m
R5154 n54255_54363 n54303_54363 8.5m
R5155 n54255_54363 n54363_54623 8.5m
xmem5156 n3397_4399 n2933_3397 l5156 memristor
R5157 n18305_18740 n18740_18856 8.5m
xmem5158 n18305_18740 n18305_19018 l5158 memristor
xmem5159 n18740_18856 n18856_19245 l5159 memristor
xmem5160 n18740_18856 n18861_18856 l5160 memristor
R5161 n6478_7427 n6284_7427 8.5m
R5162 n6478_7427 n6478_6284 8.5m
R5163 n6478_7427 n7427_7802 8.5m
R5164 n31677_32087 n31184_31677 8.5m
R5165 n11210_11021 n11210_11439 8.5m
xmem5166 n11210_11021 n8625_11210 l5166 memristor
R5167 n13159_13154 n13159_13450 8.5m
R5168 n53901_53954 n53649_53901 8.5m
xmem5169 n53901_53954 n53599_53901 l5169 memristor
xmem5170 n6978_8121 n8121_8370 l5170 memristor
xmem5171 n6978_8121 n6351_6978 l5171 memristor
R5172 n6978_8121 n8116_8121 8.5m
xmem5173 n15683_18221 n14487_15683 l5173 memristor
R5174 n15683_18221 n15444_15683 8.5m
R5175 n17980_18870 n18410_18870 8.5m
R5176 n17980_18870 n17980_18410 8.5m
xmem5177 n17980_18870 n18870_19182 l5177 memristor
R5178 n18410_18870 n18870_19182 8.5m
xmem5179 n18410_18870 n17980_18410 l5179 memristor
R5180 n18410_18870 n18410_18405 8.5m
R5181 n23429_23520 n23520_24111 8.5m
R5182 n28766_29210 n29284_29210 8.5m
xmem5183 n36232_35773 n35772_35773 l5183 memristor
xmem5184 n36232_35773 n34169_36232 l5184 memristor
R5185 n36232_35773 n35357_35773 8.5m
R5186 n35772_35773 n35357_35772 8.5m
R5187 n35772_35773 n35357_35773 8.5m
xmem5188 n35772_35773 n35161_35772 l5188 memristor
R5189 n3561_3734 n3252_3561 8.5m
R5190 n36747_37205 n36453_37205 8.5m
R5191 n36453_37205 n36380_36453 8.5m
R5192 n36453_37205 n36380_36453 8.5m
R5193 n39422_39768 n39316_39768 8.5m
R5194 n25613_26743 n26743_26752 8.5m
xmem5195 n52613_53086 n52613_52736 l5195 memristor
R5196 n52613_53086 n52346_52613 8.5m
xmem5197 n23520_24111 n23422_24111 l5197 memristor
R5198 n6425_6604 n6425_6427 8.5m
R5199 n6425_6604 n6604_7072 8.5m
xmem5200 n20403_20787 n20305_20403 l5200 memristor
xmem5201 n20403_20787 n20398_20787 l5201 memristor
R5202 n7074_7072 n6604_7072 8.5m
xmem5203 n7074_7072 n6427_7074 l5203 memristor
R5204 n7074_7072 n7299_7074 8.5m
xmem5205 n13159_13450 n13450_13730 l5205 memristor
xmem5206 n20109_20990 n20899_20990 l5206 memristor
xmem5207 n20109_20990 n20109_20899 l5207 memristor
xmem5208 n20109_20990 n20107_20109 l5208 memristor
xmem5209 n20899_20990 n20109_20899 l5209 memristor
xmem5210 n20899_20990 n21001_20899 l5210 memristor
xmem5211 n17865_18404 n18404_18866 l5211 memristor
R5212 n17865_18404 n18405_18404 8.5m
xmem5213 n17865_18404 n17794_17865 l5213 memristor
R5214 n17865_18404 n17865_18236 8.5m
xmem5215 n18404_18866 n18405_18404 l5215 memristor
R5216 n18404_18866 n18866_19255 8.5m
R5217 n18404_18866 n18866_19098 8.5m
xmem5218 n52562_53003 n52562_53645 l5218 memristor
xmem5219 n27929_29030 n29030_29093 l5219 memristor
xmem5220 n27929_29030 n27930_27929 l5220 memristor
xmem5221 n30262_30366 n30366_31094 l5221 memristor
R5222 n24090_24084 n23297_24090 8.5m
R5223 n54623_55517 n55517_55640 8.5m
R5224 n54623_55517 n54255_54623 8.5m
xmem5225 n54623_55517 n55517_55640 l5225 memristor
R5226 n54623_55517 n54363_54623 8.5m
R5227 n43479_44240 n43117_43479 8.5m
xmem5228 n43479_44240 n44240_46637 l5228 memristor
xmem5229 n53340_53917 n53026_53340 l5229 memristor
R5230 n46728_47120 n47120_47649 8.5m
xmem5231 n47120_47649 n47527_47649 l5231 memristor
R5232 n14316_14489 n13720_14316 8.5m
R5233 n14316_14489 n13813_14489 8.5m
xmem5234 n14316_14489 n14316_14488 l5234 memristor
xmem5235 n48174_48481 n48174_48405 l5235 memristor
xmem5236 n4867_6156 n6156_6219 l5236 memristor
R5237 n24525_29049 n24524_24525 8.5m
R5238 n24524_24525 n24524_25689 8.5m
R5239 n46623_47002 n46623_46619 8.5m
R5240 n28009_27936 n27936_27856 8.5m
xmem5241 n28009_27936 n27365_28009 l5241 memristor
R5242 n28009_27936 n28009_28591 8.5m
R5243 n27936_27856 n27856_28455 8.5m
xmem5244 n27936_27856 n27729_27856 l5244 memristor
R5245 n4095_4836 n4836_4949 8.5m
R5246 n32463_33921 n33921_34092 8.5m
xmem5247 n21717_22364 n21242_21717 l5247 memristor
R5248 n47054_47443 n47443_47576 8.5m
xmem5249 n6284_7427 n6478_6284 l5249 memristor
R5250 n6284_7427 n7427_7802 8.5m
R5251 n45265_45616 n45198_45616 8.5m
xmem5252 n25180_25938 n22788_25180 l5252 memristor
R5253 n25180_25938 n25938_26027 8.5m
R5254 n25180_25938 n25938_26027 8.5m
xmem5255 n8899_9161 n8899_10453 l5255 memristor
R5256 n8899_9161 n8619_8899 8.5m
R5257 n49913_50175 n50175_50176 8.5m
xmem5258 n49913_50175 n48993_49913 l5258 memristor
R5259 n49913_50175 n49996_50175 8.5m
R5260 n49913_50175 n49913_49996 8.5m
R5261 n50175_50176 n49996_50175 8.5m
xmem5262 n39316_39768 n39316_40345 l5262 memristor
R5263 n39316_40345 n40345_40563 8.5m
xmem5264 n27118_27672 n26287_27118 l5264 memristor
R5265 n27118_27672 n27672_28178 8.5m
R5266 n13530_14006 n14006_14079 8.5m
R5267 n7299_7074 n6427_7074 8.5m
R5268 n55055_55228 n54754_55055 8.5m
xmem5269 n55055_55228 n55055_55174 l5269 memristor
R5270 n54222_54402 n54402_54600 8.5m
xmem5271 n31663_32344 n31988_32344 l5271 memristor
R5272 n31435_32037 n32037_33557 8.5m
R5273 n31435_32037 n31435_31438 8.5m
xmem5274 n31435_32037 n30177_31435 l5274 memristor
R5275 n31435_32037 n32037_32394 8.5m
R5276 n32037_33557 n32037_32394 8.5m
xmem5277 n38360_38719 n37291_38360 l5277 memristor
xmem5278 n38360_38719 n38360_38293 l5278 memristor
R5279 n29030_29093 n29093_29342 8.5m
R5280 n49435_49769 n49769_49820 8.5m
xmem5281 n6427_7074 n6425_6427 l5281 memristor
xmem5282 n48708_48701 n48708_48923 l5282 memristor
xmem5283 n48708_48701 n48318_48701 l5283 memristor
xmem5284 n48708_48701 n48031_48708 l5284 memristor
xmem5285 n3534_4047 n4047_4120 l5285 memristor
R5286 n3534_4047 n3476_3534 8.5m
R5287 n48993_49913 n49913_49996 8.5m
xmem5288 n48993_49913 n49505_48993 l5288 memristor
xmem5289 n28589_28591 n28009_28591 l5289 memristor
R5290 n28589_28591 n28591_28892 8.5m
xmem5291 n28009_28591 n28591_28892 l5291 memristor
R5292 n28009_28591 n27365_28009 8.5m
xmem5293 n33259_33372 n33259_34006 l5293 memristor
R5294 n54303_54363 n54363_54623 8.5m
R5295 n54303_54363 n54146_54303 8.5m
xmem5296 n54363_54623 n54255_54623 l5296 memristor
R5297 n11210_11439 n11433_11439 8.5m
R5298 n11210_11439 n8625_11210 8.5m
xmem5299 n45973_46432 n45973_46319 l5299 memristor
xmem5300 n20256_22888 n19951_20256 l5300 memristor
R5301 n20256_22888 n22888_24902 8.5m
R5302 n33339_33437 n33346_33437 8.5m
R5303 n21777_21857 n21691_21857 8.5m
R5304 n21691_21857 n21306_21691 8.5m
R5305 n21691_21857 n21413_21691 8.5m
R5306 n45663_47940 n47940_48013 8.5m
R5307 n45663_47940 n47940_48544 8.5m
R5308 n45663_47940 n45663_45734 8.5m
R5309 n47940_48013 n47940_48544 8.5m
R5310 n47940_48013 n48013_48544 8.5m
xmem5311 n47940_48013 n48097_48013 l5311 memristor
R5312 n3657_3662 n3657_3758 8.5m
xmem5313 n33054_33267 n32966_33267 l5313 memristor
R5314 n33054_33267 n33054_33855 8.5m
R5315 n33054_33267 n33267_33755 8.5m
R5316 n33054_33267 n30586_33054 8.5m
xmem5317 n32966_33267 n33267_33755 l5317 memristor
R5318 n21811_22138 n21811_22012 8.5m
R5319 n10792_10789 n10177_10789 8.5m
R5320 n10792_10789 n10792_11040 8.5m
R5321 n10792_10789 n8923_10792 8.5m
R5322 n37897_38052 n37896_38052 8.5m
xmem5323 n28256_29188 n29188_28910 l5323 memristor
R5324 n20107_19891 n20107_20109 8.5m
xmem5325 n20107_19891 n19600_19891 l5325 memristor
xmem5326 n20107_19891 n21660_19891 l5326 memristor
R5327 n22788_25180 n22788_23849 8.5m
xmem5328 n22788_25180 n21888_22788 l5328 memristor
xmem5329 n46484_46780 n46780_47259 l5329 memristor
R5330 n46484_46780 n46484_46637 8.5m
xmem5331 n223_234 n234_363 l5331 memristor
R5332 n23849_25310 n23849_23920 8.5m
xmem5333 n23849_25310 n22788_23849 l5333 memristor
R5334 n23849_25310 n25310_26716 8.5m
xmem5335 n16499_16497 n16658_16497 l5335 memristor
R5336 n23673_24902 n22888_24902 8.5m
R5337 n23673_24902 n24902_25766 8.5m
xmem5338 n47940_48544 n48097_48544 l5338 memristor
R5339 n47940_48544 n48013_48544 8.5m
xmem5340 n53275_53514 n52736_53275 l5340 memristor
xmem5341 n31130_31289 n31119_31130 l5341 memristor
R5342 n31130_31289 n31130_31277 8.5m
R5343 n46484_46637 n44240_46637 8.5m
R5344 n8345_8578 n8338_8345 8.5m
xmem5345 n8345_8578 n8578_8643 l5345 memristor
xmem5346 n8345_8578 n8578_8643 l5346 memristor
R5347 n8345_8578 n8338_8345 8.5m
R5348 n14999_14765 n14610_14765 8.5m
xmem5349 n41625_41751 n41751_41752 l5349 memristor
R5350 n41625_41751 n41200_41625 8.5m
xmem5351 n33054_33855 n33855_33744 l5351 memristor
R5352 n33054_33855 n30586_33054 8.5m
xmem5353 n33054_33855 n33855_34304 l5353 memristor
R5354 n31267_31541 n31541_31342 8.5m
xmem5355 n21001_20899 n20109_20899 l5355 memristor
R5356 n29161_29863 n29164_29161 8.5m
xmem5357 n55826_55827 n55827_57411 l5357 memristor
R5358 n55826_55827 n55827_55900 8.5m
R5359 n39701_40822 n39701_40647 8.5m
R5360 n39701_40822 n39696_40822 8.5m
R5361 n39701_40822 n39696_39701 8.5m
xmem5362 n15787_15789 n15225_15787 l5362 memristor
xmem5363 n15787_15789 n14901_15787 l5363 memristor
R5364 n26087_26444 n26087_26336 8.5m
xmem5365 n33855_33744 n33614_33744 l5365 memristor
R5366 n33855_33744 n33855_34304 8.5m
xmem5367 n50906_51243 n51243_51556 l5367 memristor
R5368 n50906_51243 n51243_51555 8.5m
R5369 n51243_51556 n51243_51555 8.5m
R5370 n12927_13720 n13720_14316 8.5m
R5371 n18866_19098 n19098_19401 8.5m
R5372 n18866_19098 n18866_19255 8.5m
xmem5373 n7427_7802 n7802_8127 l5373 memristor
R5374 n37896_38052 n37890_37896 8.5m
R5375 n22371_22374 n22374_22584 8.5m
xmem5376 n22371_22374 n22211_22371 l5376 memristor
xmem5377 n40911_40908 n40911_41200 l5377 memristor
R5378 n40911_40908 n40908_41258 8.5m
xmem5379 n40911_41200 n41200_41625 l5379 memristor
R5380 n40911_41200 n41200_41263 8.5m
xmem5381 n8923_10792 n10792_11040 l5381 memristor
xmem5382 n8923_10792 n8923_10177 l5382 memristor
R5383 n29576_30140 n30140_30559 8.5m
R5384 n16671_16955 n16671_16593 8.5m
xmem5385 n52613_52736 n52736_53275 l5385 memristor
R5386 n52613_52736 n52346_52613 8.5m
R5387 n22102_22403 n22102_22308 8.5m
xmem5388 n22102_22403 n21660_22102 l5388 memristor
R5389 n22102_22308 n21660_22102 8.5m
R5390 n27192_28455 n27856_28455 8.5m
xmem5391 n27856_28455 n27729_27856 l5391 memristor
R5392 n54754_55055 n55055_55174 8.5m
xmem5393 n8841_8773 n8773_8776 l5393 memristor
R5394 n16276_16277 n16276_17133 8.5m
xmem5395 n16276_16277 n16043_16276 l5395 memristor
R5396 n46780_47259 n47259_47639 8.5m
xmem5397 n46780_47259 n46574_47259 l5397 memristor
xmem5398 n10945_10948 n10674_10948 l5398 memristor
R5399 n56638_56828 n56418_56638 8.5m
R5400 n14736_14960 n15275_14960 8.5m
R5401 n15275_14960 n13992_15275 8.5m
R5402 n39696_40822 n39696_39701 8.5m
R5403 n45994_46395 n45379_45994 8.5m
xmem5404 n19255_19405 n18866_19255 l5404 memristor
R5405 n19255_19405 n19405_19868 8.5m
R5406 n42371_46123 n46123_46113 8.5m
xmem5407 n42371_46123 n42037_42371 l5407 memristor
xmem5408 n42371_46123 n41316_42371 l5408 memristor
R5409 n42371_46123 n46123_46113 8.5m
xmem5410 n46123_46113 n46113_46604 l5410 memristor
R5411 n50349_50413 n49811_50349 8.5m
R5412 n24903_25771 n23857_24903 8.5m
xmem5413 n24903_25771 n25766_25771 l5413 memristor
xmem5414 n22407_22326 n22326_22615 l5414 memristor
xmem5415 n22407_22326 n22325_22326 l5415 memristor
xmem5416 n22407_22326 n22235_22407 l5416 memristor
R5417 n22407_22326 n22407_22615 8.5m
R5418 n22326_22615 n22407_22615 8.5m
xmem5419 n22326_22615 n22615_23297 l5419 memristor
xmem5420 n22326_22615 n22325_22326 l5420 memristor
R5421 n13816_13813 n13816_15607 8.5m
xmem5422 n13816_13813 n13813_14489 l5422 memristor
xmem5423 n13816_13813 n13442_13816 l5423 memristor
xmem5424 n13816_13813 n13623_13813 l5424 memristor
R5425 n13816_15607 n13442_13816 8.5m
R5426 n13816_15607 n15607_16001 8.5m
xmem5427 n13816_15607 n15607_16305 l5427 memristor
R5428 n35357_35772 n35161_35772 8.5m
R5429 n35357_35772 n35161_35357 8.5m
R5430 n35357_35772 n35357_35773 8.5m
R5431 n50400_50335 n50335_51702 8.5m
R5432 n50400_50335 n50246_50335 8.5m
R5433 n50335_51702 n50246_50335 8.5m
R5434 n50335_51702 n50678_51702 8.5m
R5435 n50335_51702 n51702_52117 8.5m
xmem5436 n19870_19868 n19405_19868 l5436 memristor
xmem5437 n19870_19868 n19870_19951 l5437 memristor
xmem5438 n25949_26291 n26816_26291 l5438 memristor
xmem5439 n18949_19874 n18949_18948 l5439 memristor
R5440 n50715_50665 n50715_50905 8.5m
R5441 n31130_31277 n31119_31130 8.5m
xmem5442 n23549_23834 n23834_23829 l5442 memristor
R5443 n23549_23834 n22851_23549 8.5m
xmem5444 n23549_23834 n23834_24876 l5444 memristor
xmem5445 n23834_23829 n23834_24876 l5445 memristor
R5446 n32037_32394 n32394_33065 8.5m
xmem5447 n45996_46619 n46619_47318 l5447 memristor
R5448 n45996_46619 n46623_46619 8.5m
R5449 n45840_45379 n45379_45994 8.5m
xmem5450 n45840_45379 n45311_45379 l5450 memristor
R5451 n45379_45994 n45311_45379 8.5m
xmem5452 n16276_17133 n16970_17133 l5452 memristor
R5453 n16276_17133 n17133_17819 8.5m
xmem5454 n16276_17133 n16043_16276 l5454 memristor
xmem5455 n16970_17133 n16269_16970 l5455 memristor
xmem5456 n16970_17133 n17133_17819 l5456 memristor
R5457 n21745_21747 n21745_22508 8.5m
R5458 n46795_46794 n46663_46794 8.5m
R5459 n28321_28910 n29188_28910 8.5m
R5460 n55144_56506 n54555_56506 8.5m
R5461 n59157_59370 n59110_59157 8.5m
xmem5462 n12870_13266 n12645_12870 l5462 memristor
R5463 n27948_28326 n27805_27948 8.5m
R5464 n14356_15081 n15081_15406 8.5m
R5465 n14356_15081 n13951_14356 8.5m
xmem5466 n14356_15081 n15081_17038 l5466 memristor
R5467 n15081_15406 n15081_17038 8.5m
R5468 n22799_22903 n22806_22799 8.5m
R5469 n24593_23920 n23849_23920 8.5m
xmem5470 n23849_23920 n22788_23849 l5470 memristor
R5471 n52449_52645 n52450_52645 8.5m
R5472 n52449_52645 n52450_52645 8.5m
R5473 n47382_47506 n47506_47838 8.5m
R5474 n47382_47506 n47506_47763 8.5m
R5475 n47506_47838 n47838_48955 8.5m
R5476 n47506_47838 n47506_47763 8.5m
xmem5477 n47066_47527 n47527_47649 l5477 memristor
R5478 n47066_47527 n47066_47124 8.5m
xmem5479 n47066_47527 n47527_48097 l5479 memristor
xmem5480 n47066_47527 n46787_47066 l5480 memristor
R5481 n47527_47649 n47527_48097 8.5m
R5482 n54146_54359 n54146_54303 8.5m
xmem5483 n54146_54359 n53749_54146 l5483 memristor
R5484 n19289_20376 n20495_20376 8.5m
xmem5485 n19289_20376 n18980_19289 l5485 memristor
R5486 n19289_20376 n20376_21666 8.5m
R5487 n19289_20376 n18980_19289 8.5m
xmem5488 n20495_20376 n20376_21666 l5488 memristor
xmem5489 n55683_55677 n55677_56147 l5489 memristor
R5490 n52562_53645 n53645_53649 8.5m
xmem5491 n25033_23911 n23458_23911 l5491 memristor
R5492 n25033_23911 n23911_24137 8.5m
xmem5493 n25168_26010 n26010_26249 l5493 memristor
R5494 n55827_55900 n55827_57411 8.5m
R5495 n55827_55900 n55900_55987 8.5m
R5496 n26803_26994 n26716_26803 8.5m
R5497 n17289_17224 n16541_17224 8.5m
R5498 n37291_38360 n38360_38293 8.5m
R5499 n15444_15450 n15444_15683 8.5m
R5500 n2933_3146 n2933_3397 8.5m
xmem5501 n49359_49904 n49904_50423 l5501 memristor
xmem5502 n49359_49904 n49904_49820 l5502 memristor
xmem5503 n20109_20899 n20107_20109 l5503 memristor
R5504 n45311_45226 n45311_45379 8.5m
R5505 n58160_58044 n57678_58160 8.5m
R5506 n58160_58044 n57678_58160 8.5m
R5507 n5112_6069 n5112_6317 8.5m
R5508 n5112_6069 n6069_6074 8.5m
xmem5509 n43777_43843 n43373_43777 l5509 memristor
R5510 n8923_10177 n10177_10789 8.5m
xmem5511 n9628_10349 n8527_9628 l5511 memristor
R5512 n10350_11003 n11003_11497 8.5m
xmem5513 n10350_11003 n11003_11339 l5513 memristor
xmem5514 n51547_52102 n51555_51547 l5514 memristor
R5515 n51547_52102 n52102_51742 8.5m
xmem5516 n51547_52102 n51485_51547 l5516 memristor
R5517 n36882_37343 n36882_36562 8.5m
R5518 n36882_37343 n37257_37343 8.5m
R5519 n49913_49996 n49996_50175 8.5m
R5520 n6472_7344 n5690_6472 8.5m
R5521 n6472_7344 n7344_8057 8.5m
xmem5522 n21954_21958 n21954_22691 l5522 memristor
R5523 n14264_14515 n14426_14264 8.5m
R5524 n14264_14515 n14264_14610 8.5m
xmem5525 n52433_52974 n52433_52439 l5525 memristor
R5526 n2933_3397 n2933_3146 8.5m
R5527 n13623_13813 n13813_14489 8.5m
xmem5528 n11339_11497 n11003_11497 l5528 memristor
xmem5529 n11339_11497 n11003_11339 l5529 memristor
R5530 n11339_11497 n11003_11339 8.5m
R5531 n11339_11497 n11003_11497 8.5m
R5532 n47318_47759 n47763_47759 8.5m
R5533 n47318_47759 n46619_47318 8.5m
xmem5534 n31818_33115 n33115_33346 l5534 memristor
R5535 n31818_33115 n31668_31818 8.5m
xmem5536 n33115_33346 n33352_33346 l5536 memristor
R5537 n33115_33346 n33346_33437 8.5m
R5538 n23691_24528 n24528_24730 8.5m
R5539 n18405_18404 n18236_18405 8.5m
R5540 n18405_18404 n18410_18405 8.5m
xmem5541 n14992_15225 n15225_15787 l5541 memristor
xmem5542 n15225_15787 n14901_15787 l5542 memristor
xmem5543 n40908_41258 n41258_41263 l5543 memristor
R5544 n40908_41258 n41258_41253 8.5m
xmem5545 n41258_41263 n41258_41253 l5545 memristor
xmem5546 n41258_41263 n41200_41263 l5546 memristor
R5547 n41258_41263 n41263_41623 8.5m
R5548 n24412_24414 n24137_24414 8.5m
xmem5549 n24412_24414 n24412_25745 l5549 memristor
R5550 n24137_24414 n23911_24137 8.5m
R5551 n55183_55236 n55236_55429 8.5m
R5552 n55183_55236 n55236_55239 8.5m
R5553 n17728_17744 n17728_17875 8.5m
R5554 n10652_11853 n11853_11857 8.5m
xmem5555 n17935_18065 n18896_17935 l5555 memristor
xmem5556 n17935_18065 n17487_17935 l5556 memristor
R5557 n17935_18065 n18065_18892 8.5m
xmem5558 n43373_43709 n43373_43777 l5558 memristor
xmem5559 n21660_19891 n19600_19891 l5559 memristor
R5560 n21660_19891 n21660_22102 8.5m
xmem5561 n14079_14244 n14006_14079 l5561 memristor
xmem5562 n53749_54146 n54146_54303 l5562 memristor
xmem5563 n53749_54146 n54189_53749 l5563 memristor
R5564 n25310_26716 n26716_26803 8.5m
xmem5565 n14610_14765 n14264_14610 l5565 memristor
xmem5566 n4372_4680 n4372_4818 l5566 memristor
R5567 n54936_54934 n54934_55019 8.5m
xmem5568 n54936_54934 n54812_54934 l5568 memristor
xmem5569 n54934_55019 n55019_55846 l5569 memristor
xmem5570 n54934_55019 n54812_54934 l5570 memristor
xmem5571 n8121_8370 n8436_8370 l5571 memristor
xmem5572 n8121_8370 n8116_8121 l5572 memristor
xmem5573 n8121_8370 n8370_8730 l5573 memristor
R5574 n46113_46604 n46604_48057 8.5m
R5575 n46113_46604 n46604_48264 8.5m
R5576 n46113_46604 n46123_46113 8.5m
R5577 n46604_48057 n48057_48272 8.5m
R5578 n46604_48057 n46604_48264 8.5m
xmem5579 n42037_42371 n41316_42371 l5579 memristor
R5580 n20521_21039 n17166_20521 8.5m
R5581 n20521_21039 n20521_21230 8.5m
xmem5582 n8116_8436 n8436_8370 l5582 memristor
R5583 n8116_8436 n8116_8121 8.5m
R5584 n8116_8436 n7792_8116 8.5m
R5585 n8436_8370 n8370_8730 8.5m
R5586 n10609_10606 n10609_10613 8.5m
R5587 n10609_10606 n9930_10609 8.5m
R5588 n10609_10606 n10189_10606 8.5m
R5589 n10609_10613 n9930_10609 8.5m
R5590 n10609_10613 n10613_11066 8.5m
xmem5591 n48097_48544 n48013_48544 l5591 memristor
R5592 n48097_48544 n47527_48097 8.5m
R5593 n48097_48544 n48097_48013 8.5m
xmem5594 n48013_48544 n48097_48013 l5594 memristor
R5595 n20457_20345 n19867_20345 8.5m
R5596 n20457_20345 n19487_20345 8.5m
xmem5597 n20457_20345 n19401_20457 l5597 memristor
xmem5598 n31435_31438 n30177_31435 l5598 memristor
R5599 n16484_17166 n15433_16484 8.5m
xmem5600 n16484_17166 n17166_20521 l5600 memristor
R5601 n16484_17166 n17166_20521 8.5m
R5602 n16484_17166 n15433_16484 8.5m
R5603 n52067_52117 n51702_52117 8.5m
R5604 n52067_52117 n52117_52832 8.5m
xmem5605 n36311_36721 n35446_36311 l5605 memristor
R5606 n36311_36721 n35446_36311 8.5m
R5607 n18861_18856 n18856_19245 8.5m
R5608 n26188_27564 n27564_28052 8.5m
xmem5609 n26188_27564 n27564_27313 l5609 memristor
xmem5610 n27564_28052 n27564_27313 l5610 memristor
R5611 n46574_47259 n47259_47639 8.5m
R5612 n606_1614 n1614_2731 8.5m
xmem5613 n16418_16491 n16305_16418 l5613 memristor
xmem5614 n16418_16491 n16302_16418 l5614 memristor
xmem5615 n55900_55987 n55987_56418 l5615 memristor
R5616 n13998_13992 n13992_15275 8.5m
xmem5617 n13998_13992 n13712_13992 l5617 memristor
xmem5618 n13992_15275 n13712_13992 l5618 memristor
R5619 n13394_13490 n12491_13394 8.5m
R5620 n13394_13490 n13394_13951 8.5m
R5621 n19220_19434 n19220_20497 8.5m
xmem5622 n6740_6828 n6074_6828 l5622 memristor
xmem5623 n6740_6828 n6740_7945 l5623 memristor
xmem5624 n6740_6828 n7694_6828 l5624 memristor
R5625 n17794_17865 n17865_18236 8.5m
xmem5626 n17794_17865 n17329_17794 l5626 memristor
R5627 n17865_18236 n18236_18405 8.5m
R5628 n24443_24730 n24528_24730 8.5m
R5629 n17166_20521 n20521_21230 8.5m
R5630 n10726_10727 n10727_11658 8.5m
R5631 n10726_10727 n10727_12258 8.5m
xmem5632 n10727_11658 n10727_12258 l5632 memristor
xmem5633 n10727_11658 n11658_12262 l5633 memristor
xmem5634 n19547_20504 n18809_19547 l5634 memristor
R5635 n19547_20504 n19449_19547 8.5m
xmem5636 n7344_8057 n8057_8184 l5636 memristor
xmem5637 n56955_57021 n56863_56955 l5637 memristor
xmem5638 n19571_20078 n18846_19571 l5638 memristor
xmem5639 n45271_45482 n44835_45271 l5639 memristor
xmem5640 n17980_18410 n18410_18405 l5640 memristor
R5641 n20376_21666 n21666_21983 8.5m
R5642 n23911_24137 n23458_23911 8.5m
xmem5643 n2731_2663 n2663_4279 l5643 memristor
R5644 n2731_2663 n1614_2731 8.5m
R5645 n2731_2663 n2731_3304 8.5m
R5646 n2663_4279 n3304_4279 8.5m
R5647 n49820_50108 n49769_49820 8.5m
R5648 n49820_50108 n49904_49820 8.5m
R5649 n25562_25636 n24863_25562 8.5m
xmem5650 n37626_37738 n37738_37936 l5650 memristor
xmem5651 n14426_14264 n14264_14610 l5651 memristor
R5652 n47875_48031 n48031_48708 8.5m
R5653 n19951_20256 n19870_19951 8.5m
R5654 n49769_49820 n49904_49820 8.5m
R5655 n6981_6987 n6987_7267 8.5m
xmem5656 n23297_24090 n23297_23700 l5656 memristor
R5657 n23297_24090 n22615_23297 8.5m
xmem5658 n22965_23458 n23458_23911 l5658 memristor
R5659 n30366_31094 n31094_31258 8.5m
R5660 n15607_16305 n15607_16001 8.5m
R5661 n15607_16305 n16305_16418 8.5m
R5662 n15081_17038 n17038_17039 8.5m
xmem5663 n17487_17935 n18896_17935 l5663 memristor
xmem5664 n17487_17935 n17487_17993 l5664 memristor
xmem5665 n16043_16108 n16043_16276 l5665 memristor
R5666 n16043_16108 n15411_16043 8.5m
xmem5667 n16043_16108 n16108_16269 l5667 memristor
xmem5668 n16043_16276 n15411_16043 l5668 memristor
R5669 n16878_16863 n16863_17182 8.5m
R5670 n16863_17182 n17180_17182 8.5m
R5671 n16863_17182 n17180_17182 8.5m
xmem5672 n47066_47124 n46787_47066 l5672 memristor
R5673 n29515_29512 n29515_29810 8.5m
R5674 n29515_29512 n29512_29607 8.5m
R5675 n38119_38121 n38121_38500 8.5m
xmem5676 n47838_48955 n48955_49138 l5676 memristor
R5677 n18973_19600 n19600_19891 8.5m
xmem5678 n45198_45616 n45265_45616 l5678 memristor
xmem5679 n31184_31677 n31184_31189 l5679 memristor
xmem5680 n57453_57887 n57551_57453 l5680 memristor
xmem5681 n41767_42874 n42874_42886 l5681 memristor
R5682 n41767_42874 n42874_42994 8.5m
xmem5683 n8578_8643 n8643_9208 l5683 memristor
R5684 n8578_8643 n7094_8643 8.5m
R5685 n8758_11878 n11878_11882 8.5m
R5686 n8758_11878 n8758_11540 8.5m
R5687 n15133_15709 n15709_16953 8.5m
R5688 n21888_22788 n22788_23849 8.5m
R5689 n12184_12262 n11658_12262 8.5m
R5690 n59111_59110 n59111_59322 8.5m
R5691 n59111_59110 n59110_59157 8.5m
xmem5692 n13848_13756 n13757_13756 l5692 memristor
xmem5693 n21413_21691 n21306_21691 l5693 memristor
R5694 n5823_6118 n6118_6545 8.5m
R5695 n6118_6545 n6545_7844 8.5m
R5696 n11003_11497 n11003_11339 8.5m
xmem5697 n48174_48405 n48318_48405 l5697 memristor
R5698 n18809_19547 n19449_19547 8.5m
R5699 n34169_35161 n35161_35357 8.5m
R5700 n34169_35161 n34169_36232 8.5m
xmem5701 n34169_35161 n35161_35772 l5701 memristor
R5702 n35161_35357 n35357_35773 8.5m
R5703 n35161_35357 n35161_35772 8.5m
xmem5704 n17957_18081 n17568_17957 l5704 memristor
xmem5705 n13930_13924 n14029_13924 l5705 memristor
R5706 n13930_13924 n14029_13924 8.5m
xmem5707 n33346_33437 n33352_33346 l5707 memristor
R5708 n14193_14437 n14194_14437 8.5m
R5709 n22407_22615 n22615_23297 8.5m
xmem5710 n22407_22615 n22235_22407 l5710 memristor
xmem5711 n22615_23297 n23297_23700 l5711 memristor
R5712 n8643_9208 n7094_8643 8.5m
xmem5713 n42400_42569 n42465_42569 l5713 memristor
xmem5714 n16596_16593 n16671_16593 l5714 memristor
R5715 n19401_20457 n19098_19401 8.5m
R5716 n29342_29806 n29342_30369 8.5m
R5717 n29342_29806 n29093_29342 8.5m
R5718 n29342_29806 n29806_29868 8.5m
xmem5719 n24633_24828 n24837_24828 l5719 memristor
R5720 n4596_4795 n4803_4596 8.5m
R5721 n18236_18405 n18410_18405 8.5m
xmem5722 n22780_23075 n23075_24219 l5722 memristor
R5723 n46619_47318 n46623_46619 8.5m
R5724 n48708_48923 n48031_48708 8.5m
xmem5725 n42465_42569 n41282_42465 l5725 memristor
xmem5726 n19802_20470 n20470_20576 l5726 memristor
xmem5727 n56418_56638 n55987_56418 l5727 memristor
R5728 n54570_54641 n54570_54572 8.5m
xmem5729 n5260_6074 n6074_6828 l5729 memristor
xmem5730 n5260_6074 n6069_6074 l5730 memristor
R5731 n6074_6828 n7694_6828 8.5m
R5732 n6074_6828 n6069_6074 8.5m
R5733 n27223_27630 n27630_28195 8.5m
R5734 n27223_27630 n27031_27630 8.5m
R5735 n27630_28195 n27031_27630 8.5m
xmem5736 n50678_51702 n51702_52117 l5736 memristor
xmem5737 n51702_52117 n52117_52832 l5737 memristor
xmem5738 n17568_17957 n17171_17568 l5738 memristor
R5739 n24653_24312 n21600_24312 8.5m
R5740 n22851_23549 n22851_22855 8.5m
xmem5741 n10026_10331 n9456_10026 l5741 memristor
xmem5742 n10026_10331 n10026_9930 l5742 memristor
xmem5743 n16108_16269 n16269_16970 l5743 memristor
xmem5744 n30646_30701 n30384_30701 l5744 memristor
R5745 n30646_30701 n30701_30989 8.5m
R5746 n30384_30701 n29810_30384 8.5m
R5747 n30384_30701 n30701_30989 8.5m
R5748 n15607_16001 n15691_16001 8.5m
R5749 n8510_9034 n9034_8940 8.5m
xmem5750 n10026_9930 n9930_10609 l5750 memristor
R5751 n10026_9930 n9456_10026 8.5m
R5752 n10026_9930 n9858_9930 8.5m
R5753 n9930_10609 n9858_9930 8.5m
R5754 n19911_21395 n21395_21194 8.5m
R5755 n19911_21395 n21395_21403 8.5m
R5756 n51555_51547 n51555_51742 8.5m
R5757 n51555_51547 n51485_51547 8.5m
R5758 n51555_51547 n51243_51555 8.5m
R5759 n8899_10453 n8619_8899 8.5m
xmem5760 n34304_34220 n34304_39173 l5760 memristor
R5761 n34304_34220 n33855_34304 8.5m
xmem5762 n34304_39173 n33855_34304 l5762 memristor
R5763 n17329_17107 n17329_17794 8.5m
R5764 n48272_48942 n48057_48272 8.5m
R5765 n48272_48942 n48057_48272 8.5m
R5766 n24902_25766 n25766_25771 8.5m
R5767 n24902_25766 n25766_27805 8.5m
xmem5768 n24902_25766 n22888_24902 l5768 memristor
xmem5769 n25766_25771 n25766_27805 l5769 memristor
R5770 n56881_57094 n57094_57575 8.5m
xmem5771 n56881_57094 n57094_57640 l5771 memristor
R5772 n57094_57575 n57094_57640 8.5m
xmem5773 n42874_42886 n42874_42994 l5773 memristor
R5774 n53649_53901 n53599_53901 8.5m
xmem5775 n53649_53901 n53645_53649 l5775 memristor
xmem5776 n7094_7096 n7094_8643 l5776 memristor
R5777 n7094_7096 n5898_7094 8.5m
R5778 n7094_8643 n5898_7094 8.5m
R5779 n41258_41253 n41252_41253 8.5m
xmem5780 n29688_30584 n29758_30584 l5780 memristor
xmem5781 n29688_30584 n29458_29688 l5781 memristor
R5782 n29342_30369 n29093_29342 8.5m
R5783 n32232_32233 n32233_32903 8.5m
xmem5784 n13720_14316 n14316_14488 l5784 memristor
xmem5785 n14487_15683 n15444_15683 l5785 memristor
R5786 n4372_4818 n4818_4812 8.5m
R5787 n13389_13951 n13951_14356 8.5m
R5788 n13389_13951 n13394_13951 8.5m
R5789 n13951_14356 n13394_13951 8.5m
xmem5790 n19867_20345 n19487_20345 l5790 memristor
xmem5791 n21155_21246 n21242_21246 l5791 memristor
xmem5792 n7694_6828 n7694_8167 l5792 memristor
R5793 n51243_51555 n51555_51742 8.5m
xmem5794 n23857_24903 n23577_23857 l5794 memristor
R5795 n25766_27805 n27805_27948 8.5m
R5796 n25766_27805 n27805_27744 8.5m
R5797 n25589_26125 n26125_26019 8.5m
R5798 n25589_26125 n25589_26019 8.5m
R5799 n22750_22757 n22757_23823 8.5m
R5800 n29810_30384 n29515_29810 8.5m
R5801 n8129_8619 n8063_8619 8.5m
xmem5802 n8129_8619 n8619_8899 l5802 memristor
R5803 n8063_8619 n8619_8899 8.5m
xmem5804 n1614_2731 n2731_3304 l5804 memristor
R5805 n8912_8910 n8316_8912 8.5m
R5806 n8912_8910 n8912_9329 8.5m
xmem5807 n41200_41625 n41200_41263 l5807 memristor
xmem5808 n24970_25305 n24219_24970 l5808 memristor
R5809 n15237_17215 n17215_17478 8.5m
R5810 n8799_8803 n8804_8803 8.5m
R5811 n8799_8803 n8803_9615 8.5m
R5812 n49904_49820 n49904_50423 8.5m
xmem5813 n12242_14119 n12079_12242 l5813 memristor
R5814 n22757_23823 n23828_23823 8.5m
xmem5815 n22757_23823 n23823_24200 l5815 memristor
xmem5816 n23828_23823 n23823_24200 l5816 memristor
R5817 n23828_23823 n22556_23828 8.5m
xmem5818 n18175_18761 n18761_18766 l5818 memristor
R5819 n23377_23577 n23277_23577 8.5m
R5820 n23377_23577 n23577_23857 8.5m
R5821 n52102_51742 n51555_51742 8.5m
xmem5822 n52102_51742 n51742_51750 l5822 memristor
R5823 n55236_55429 n55236_55239 8.5m
R5824 n5324_5394 n4812_5324 8.5m
xmem5825 n15093_15342 n12603_15093 l5825 memristor
R5826 n12491_13394 n13394_13951 8.5m
xmem5827 n26287_27118 n26287_27112 l5827 memristor
R5828 n11878_11882 n11788_11882 8.5m
R5829 n7599_8316 n8316_8912 8.5m
R5830 n8316_8912 n8912_9329 8.5m
R5831 n9727_9564 n9389_9564 8.5m
R5832 n23075_24219 n24219_24970 8.5m
xmem5833 n55239_55433 n55236_55239 l5833 memristor
R5834 n27283_27744 n27805_27744 8.5m
xmem5835 n27283_27744 n27008_27744 l5835 memristor
R5836 n47527_48097 n48097_48013 8.5m
xmem5837 n53026_53340 n53026_53028 l5837 memristor
xmem5838 n25589_26019 n26016_26019 l5838 memristor
R5839 n25589_26019 n26125_26019 8.5m
R5840 n26016_26019 n26125_26019 8.5m
R5841 n27008_27744 n27805_27744 8.5m
R5842 n12367_12444 n12367_13712 8.5m
R5843 n37328_38138 n37237_37328 8.5m
R5844 n27805_27948 n27805_27744 8.5m
R5845 n54629_54630 n54369_54629 8.5m
R5846 n22120_22542 n22542_22639 8.5m
R5847 n41263_41623 n41200_41263 8.5m
xmem5848 n23577_23857 n23277_23577 l5848 memristor
xmem5849 n29685_29758 n29758_30584 l5849 memristor
R5850 n21306_21691 n21210_21306 8.5m
R5851 n21242_21717 n21242_21246 8.5m
xmem5852 n13712_13992 n12367_13712 l5852 memristor
R5853 n4818_4812 n4812_5324 8.5m
R5854 n10620_11066 n10613_11066 8.5m
xmem5855 n42541_44679 n42296_42541 l5855 memristor
xmem5856 n48264_48337 n46604_48264 l5856 memristor
R5857 n8803_9615 n8804_8803 8.5m
R5858 n54570_54572 n54570_54641 8.5m
xmem5859 n23422_24111 n22059_23422 l5859 memristor
xmem5860 n16305_16418 n16302_16418 l5860 memristor
R5861 n55677_56147 n56147_56063 8.5m
R5862 n51555_51742 n51742_51750 8.5m
xmem5863 n21395_21194 n21395_21403 l5863 memristor
R5864 n6740_7945 n7945_9227 8.5m
xmem5865 n36428_36957 n36957_37490 l5865 memristor
R5866 n47763_47759 n47506_47763 8.5m
R5867 n8116_8121 n7792_8116 8.5m
R5868 n39701_40647 n39696_39701 8.5m
R5869 n48318_48405 n48318_48701 8.5m
R5870 n16518_16677 n16677_17272 8.5m
R5871 n37420_37490 n36957_37490 8.5m
xmem5872 n3304_4279 n2731_3304 l5872 memristor

* ANALYSIS COMMANDS:
.tran 0.002 10.0   uic

* CONTROL COMMANDS:
.control
run
set wr_vecnames
set wr_singlescale
wrdata C:\Users\javit\Desktop\tesis-lic\memristor_simulation\memristorsimulation_app/simulation_results/pershin_simulations/p_06_1773161162/p_06_results.csv vin i(v1)

quit

.endc
.end
